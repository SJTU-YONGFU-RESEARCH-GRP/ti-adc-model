* TI static INL/DNL testbench (ngspice behavioral, channel-wise E2E + TI mux)
* Reference: veriloga/ti_channel_adc.va + ti_adc Python golden model
.param BITS=10
.param VREFP=1.0
.param VREFN=0.0
.param MAXCODE=1023
.param LSB=(1.0-0.0)/1023
.param VCM=0.5
.param VFS=1.0
.param FS=1000000000.0
.param NUM_CHANNELS=4
.param SIGMA_THERMAL=0.00025
.param NONLINEARITY_A2=0.0
.param NONLINEARITY_A3=-0.002
.param JITTER_RMS=5e-13
.param DNL_SIGMA_LSB=0.08
.param NOISE_SEED=1
.param SAMPLES_PER_CODE=16
.param NUM_SAMPLES=16384
.param DT=1.000000000000e-09
.param TSTOP=1.638400000000e-05

.options delmax=1.000000000000e-09 maxstep=1.000000000000e-09
Vin vin 0 PWL(
+ 0.000000000000e+00 4.887585532747e-04
+ 1.000000000000e-09 5.497377684913e-04
+ 2.000000000000e-09 6.107169837079e-04
+ 3.000000000000e-09 6.716961989245e-04
+ 4.000000000000e-09 7.326754141411e-04
+ 5.000000000000e-09 7.936546293576e-04
+ 6.000000000000e-09 8.546338445742e-04
+ 7.000000000000e-09 9.156130597908e-04
+ 8.000000000000e-09 9.765922750074e-04
+ 9.000000000000e-09 1.037571490224e-03
+ 1.000000000000e-08 1.098550705441e-03
+ 1.100000000000e-08 1.159529920657e-03
+ 1.200000000000e-08 1.220509135874e-03
+ 1.300000000000e-08 1.281488351090e-03
+ 1.400000000000e-08 1.342467566307e-03
+ 1.500000000000e-08 1.403446781524e-03
+ 1.600000000000e-08 1.464425996740e-03
+ 1.700000000000e-08 1.525405211957e-03
+ 1.800000000000e-08 1.586384427173e-03
+ 1.900000000000e-08 1.647363642390e-03
+ 2.000000000000e-08 1.708342857607e-03
+ 2.100000000000e-08 1.769322072823e-03
+ 2.200000000000e-08 1.830301288040e-03
+ 2.300000000000e-08 1.891280503256e-03
+ 2.400000000000e-08 1.952259718473e-03
+ 2.500000000000e-08 2.013238933690e-03
+ 2.600000000000e-08 2.074218148906e-03
+ 2.700000000000e-08 2.135197364123e-03
+ 2.800000000000e-08 2.196176579339e-03
+ 2.900000000000e-08 2.257155794556e-03
+ 3.000000000000e-08 2.318135009772e-03
+ 3.100000000000e-08 2.379114224989e-03
+ 3.200000000000e-08 2.440093440206e-03
+ 3.300000000000e-08 2.501072655422e-03
+ 3.400000000000e-08 2.562051870639e-03
+ 3.500000000000e-08 2.623031085855e-03
+ 3.600000000000e-08 2.684010301072e-03
+ 3.700000000000e-08 2.744989516289e-03
+ 3.800000000000e-08 2.805968731505e-03
+ 3.900000000000e-08 2.866947946722e-03
+ 4.000000000000e-08 2.927927161938e-03
+ 4.100000000000e-08 2.988906377155e-03
+ 4.200000000000e-08 3.049885592372e-03
+ 4.300000000000e-08 3.110864807588e-03
+ 4.400000000000e-08 3.171844022805e-03
+ 4.500000000000e-08 3.232823238021e-03
+ 4.600000000000e-08 3.293802453238e-03
+ 4.700000000000e-08 3.354781668455e-03
+ 4.800000000000e-08 3.415760883671e-03
+ 4.900000000000e-08 3.476740098888e-03
+ 5.000000000000e-08 3.537719314104e-03
+ 5.100000000000e-08 3.598698529321e-03
+ 5.200000000000e-08 3.659677744538e-03
+ 5.300000000000e-08 3.720656959754e-03
+ 5.400000000000e-08 3.781636174971e-03
+ 5.500000000000e-08 3.842615390187e-03
+ 5.600000000000e-08 3.903594605404e-03
+ 5.700000000000e-08 3.964573820621e-03
+ 5.800000000000e-08 4.025553035837e-03
+ 5.900000000000e-08 4.086532251054e-03
+ 6.000000000000e-08 4.147511466270e-03
+ 6.100000000000e-08 4.208490681487e-03
+ 6.200000000000e-08 4.269469896703e-03
+ 6.300000000000e-08 4.330449111920e-03
+ 6.400000000000e-08 4.391428327137e-03
+ 6.500000000000e-08 4.452407542353e-03
+ 6.600000000000e-08 4.513386757570e-03
+ 6.700000000000e-08 4.574365972786e-03
+ 6.800000000000e-08 4.635345188003e-03
+ 6.900000000000e-08 4.696324403220e-03
+ 7.000000000000e-08 4.757303618436e-03
+ 7.100000000000e-08 4.818282833653e-03
+ 7.200000000000e-08 4.879262048869e-03
+ 7.300000000000e-08 4.940241264086e-03
+ 7.400000000000e-08 5.001220479303e-03
+ 7.500000000000e-08 5.062199694519e-03
+ 7.600000000000e-08 5.123178909736e-03
+ 7.700000000000e-08 5.184158124952e-03
+ 7.800000000000e-08 5.245137340169e-03
+ 7.900000000000e-08 5.306116555386e-03
+ 8.000000000000e-08 5.367095770602e-03
+ 8.100000000000e-08 5.428074985819e-03
+ 8.200000000000e-08 5.489054201035e-03
+ 8.300000000000e-08 5.550033416252e-03
+ 8.400000000000e-08 5.611012631469e-03
+ 8.500000000000e-08 5.671991846685e-03
+ 8.600000000000e-08 5.732971061902e-03
+ 8.700000000000e-08 5.793950277118e-03
+ 8.800000000000e-08 5.854929492335e-03
+ 8.900000000000e-08 5.915908707552e-03
+ 9.000000000000e-08 5.976887922768e-03
+ 9.100000000000e-08 6.037867137985e-03
+ 9.200000000000e-08 6.098846353201e-03
+ 9.300000000000e-08 6.159825568418e-03
+ 9.400000000000e-08 6.220804783634e-03
+ 9.500000000000e-08 6.281783998851e-03
+ 9.600000000000e-08 6.342763214068e-03
+ 9.700000000000e-08 6.403742429284e-03
+ 9.800000000000e-08 6.464721644501e-03
+ 9.900000000000e-08 6.525700859717e-03
+ 1.000000000000e-07 6.586680074934e-03
+ 1.010000000000e-07 6.647659290151e-03
+ 1.020000000000e-07 6.708638505367e-03
+ 1.030000000000e-07 6.769617720584e-03
+ 1.040000000000e-07 6.830596935800e-03
+ 1.050000000000e-07 6.891576151017e-03
+ 1.060000000000e-07 6.952555366234e-03
+ 1.070000000000e-07 7.013534581450e-03
+ 1.080000000000e-07 7.074513796667e-03
+ 1.090000000000e-07 7.135493011883e-03
+ 1.100000000000e-07 7.196472227100e-03
+ 1.110000000000e-07 7.257451442317e-03
+ 1.120000000000e-07 7.318430657533e-03
+ 1.130000000000e-07 7.379409872750e-03
+ 1.140000000000e-07 7.440389087966e-03
+ 1.150000000000e-07 7.501368303183e-03
+ 1.160000000000e-07 7.562347518400e-03
+ 1.170000000000e-07 7.623326733616e-03
+ 1.180000000000e-07 7.684305948833e-03
+ 1.190000000000e-07 7.745285164049e-03
+ 1.200000000000e-07 7.806264379266e-03
+ 1.210000000000e-07 7.867243594482e-03
+ 1.220000000000e-07 7.928222809699e-03
+ 1.230000000000e-07 7.989202024916e-03
+ 1.240000000000e-07 8.050181240132e-03
+ 1.250000000000e-07 8.111160455349e-03
+ 1.260000000000e-07 8.172139670565e-03
+ 1.270000000000e-07 8.233118885782e-03
+ 1.280000000000e-07 8.294098100999e-03
+ 1.290000000000e-07 8.355077316215e-03
+ 1.300000000000e-07 8.416056531432e-03
+ 1.310000000000e-07 8.477035746648e-03
+ 1.320000000000e-07 8.538014961865e-03
+ 1.330000000000e-07 8.598994177082e-03
+ 1.340000000000e-07 8.659973392298e-03
+ 1.350000000000e-07 8.720952607515e-03
+ 1.360000000000e-07 8.781931822731e-03
+ 1.370000000000e-07 8.842911037948e-03
+ 1.380000000000e-07 8.903890253165e-03
+ 1.390000000000e-07 8.964869468381e-03
+ 1.400000000000e-07 9.025848683598e-03
+ 1.410000000000e-07 9.086827898814e-03
+ 1.420000000000e-07 9.147807114031e-03
+ 1.430000000000e-07 9.208786329248e-03
+ 1.440000000000e-07 9.269765544464e-03
+ 1.450000000000e-07 9.330744759681e-03
+ 1.460000000000e-07 9.391723974897e-03
+ 1.470000000000e-07 9.452703190114e-03
+ 1.480000000000e-07 9.513682405331e-03
+ 1.490000000000e-07 9.574661620547e-03
+ 1.500000000000e-07 9.635640835764e-03
+ 1.510000000000e-07 9.696620050980e-03
+ 1.520000000000e-07 9.757599266197e-03
+ 1.530000000000e-07 9.818578481413e-03
+ 1.540000000000e-07 9.879557696630e-03
+ 1.550000000000e-07 9.940536911847e-03
+ 1.560000000000e-07 1.000151612706e-02
+ 1.570000000000e-07 1.006249534228e-02
+ 1.580000000000e-07 1.012347455750e-02
+ 1.590000000000e-07 1.018445377271e-02
+ 1.600000000000e-07 1.024543298793e-02
+ 1.610000000000e-07 1.030641220315e-02
+ 1.620000000000e-07 1.036739141836e-02
+ 1.630000000000e-07 1.042837063358e-02
+ 1.640000000000e-07 1.048934984880e-02
+ 1.650000000000e-07 1.055032906401e-02
+ 1.660000000000e-07 1.061130827923e-02
+ 1.670000000000e-07 1.067228749445e-02
+ 1.680000000000e-07 1.073326670966e-02
+ 1.690000000000e-07 1.079424592488e-02
+ 1.700000000000e-07 1.085522514010e-02
+ 1.710000000000e-07 1.091620435531e-02
+ 1.720000000000e-07 1.097718357053e-02
+ 1.730000000000e-07 1.103816278575e-02
+ 1.740000000000e-07 1.109914200096e-02
+ 1.750000000000e-07 1.116012121618e-02
+ 1.760000000000e-07 1.122110043140e-02
+ 1.770000000000e-07 1.128207964661e-02
+ 1.780000000000e-07 1.134305886183e-02
+ 1.790000000000e-07 1.140403807704e-02
+ 1.800000000000e-07 1.146501729226e-02
+ 1.810000000000e-07 1.152599650748e-02
+ 1.820000000000e-07 1.158697572269e-02
+ 1.830000000000e-07 1.164795493791e-02
+ 1.840000000000e-07 1.170893415313e-02
+ 1.850000000000e-07 1.176991336834e-02
+ 1.860000000000e-07 1.183089258356e-02
+ 1.870000000000e-07 1.189187179878e-02
+ 1.880000000000e-07 1.195285101399e-02
+ 1.890000000000e-07 1.201383022921e-02
+ 1.900000000000e-07 1.207480944443e-02
+ 1.910000000000e-07 1.213578865964e-02
+ 1.920000000000e-07 1.219676787486e-02
+ 1.930000000000e-07 1.225774709008e-02
+ 1.940000000000e-07 1.231872630529e-02
+ 1.950000000000e-07 1.237970552051e-02
+ 1.960000000000e-07 1.244068473573e-02
+ 1.970000000000e-07 1.250166395094e-02
+ 1.980000000000e-07 1.256264316616e-02
+ 1.990000000000e-07 1.262362238138e-02
+ 2.000000000000e-07 1.268460159659e-02
+ 2.010000000000e-07 1.274558081181e-02
+ 2.020000000000e-07 1.280656002703e-02
+ 2.030000000000e-07 1.286753924224e-02
+ 2.040000000000e-07 1.292851845746e-02
+ 2.050000000000e-07 1.298949767268e-02
+ 2.060000000000e-07 1.305047688789e-02
+ 2.070000000000e-07 1.311145610311e-02
+ 2.080000000000e-07 1.317243531833e-02
+ 2.090000000000e-07 1.323341453354e-02
+ 2.100000000000e-07 1.329439374876e-02
+ 2.110000000000e-07 1.335537296398e-02
+ 2.120000000000e-07 1.341635217919e-02
+ 2.130000000000e-07 1.347733139441e-02
+ 2.140000000000e-07 1.353831060963e-02
+ 2.150000000000e-07 1.359928982484e-02
+ 2.160000000000e-07 1.366026904006e-02
+ 2.170000000000e-07 1.372124825528e-02
+ 2.180000000000e-07 1.378222747049e-02
+ 2.190000000000e-07 1.384320668571e-02
+ 2.200000000000e-07 1.390418590093e-02
+ 2.210000000000e-07 1.396516511614e-02
+ 2.220000000000e-07 1.402614433136e-02
+ 2.230000000000e-07 1.408712354658e-02
+ 2.240000000000e-07 1.414810276179e-02
+ 2.250000000000e-07 1.420908197701e-02
+ 2.260000000000e-07 1.427006119222e-02
+ 2.270000000000e-07 1.433104040744e-02
+ 2.280000000000e-07 1.439201962266e-02
+ 2.290000000000e-07 1.445299883787e-02
+ 2.300000000000e-07 1.451397805309e-02
+ 2.310000000000e-07 1.457495726831e-02
+ 2.320000000000e-07 1.463593648352e-02
+ 2.330000000000e-07 1.469691569874e-02
+ 2.340000000000e-07 1.475789491396e-02
+ 2.350000000000e-07 1.481887412917e-02
+ 2.360000000000e-07 1.487985334439e-02
+ 2.370000000000e-07 1.494083255961e-02
+ 2.380000000000e-07 1.500181177482e-02
+ 2.390000000000e-07 1.506279099004e-02
+ 2.400000000000e-07 1.512377020526e-02
+ 2.410000000000e-07 1.518474942047e-02
+ 2.420000000000e-07 1.524572863569e-02
+ 2.430000000000e-07 1.530670785091e-02
+ 2.440000000000e-07 1.536768706612e-02
+ 2.450000000000e-07 1.542866628134e-02
+ 2.460000000000e-07 1.548964549656e-02
+ 2.470000000000e-07 1.555062471177e-02
+ 2.480000000000e-07 1.561160392699e-02
+ 2.490000000000e-07 1.567258314221e-02
+ 2.500000000000e-07 1.573356235742e-02
+ 2.510000000000e-07 1.579454157264e-02
+ 2.520000000000e-07 1.585552078786e-02
+ 2.530000000000e-07 1.591650000307e-02
+ 2.540000000000e-07 1.597747921829e-02
+ 2.550000000000e-07 1.603845843351e-02
+ 2.560000000000e-07 1.609943764872e-02
+ 2.570000000000e-07 1.616041686394e-02
+ 2.580000000000e-07 1.622139607916e-02
+ 2.590000000000e-07 1.628237529437e-02
+ 2.600000000000e-07 1.634335450959e-02
+ 2.610000000000e-07 1.640433372481e-02
+ 2.620000000000e-07 1.646531294002e-02
+ 2.630000000000e-07 1.652629215524e-02
+ 2.640000000000e-07 1.658727137046e-02
+ 2.650000000000e-07 1.664825058567e-02
+ 2.660000000000e-07 1.670922980089e-02
+ 2.670000000000e-07 1.677020901611e-02
+ 2.680000000000e-07 1.683118823132e-02
+ 2.690000000000e-07 1.689216744654e-02
+ 2.700000000000e-07 1.695314666175e-02
+ 2.710000000000e-07 1.701412587697e-02
+ 2.720000000000e-07 1.707510509219e-02
+ 2.730000000000e-07 1.713608430740e-02
+ 2.740000000000e-07 1.719706352262e-02
+ 2.750000000000e-07 1.725804273784e-02
+ 2.760000000000e-07 1.731902195305e-02
+ 2.770000000000e-07 1.738000116827e-02
+ 2.780000000000e-07 1.744098038349e-02
+ 2.790000000000e-07 1.750195959870e-02
+ 2.800000000000e-07 1.756293881392e-02
+ 2.810000000000e-07 1.762391802914e-02
+ 2.820000000000e-07 1.768489724435e-02
+ 2.830000000000e-07 1.774587645957e-02
+ 2.840000000000e-07 1.780685567479e-02
+ 2.850000000000e-07 1.786783489000e-02
+ 2.860000000000e-07 1.792881410522e-02
+ 2.870000000000e-07 1.798979332044e-02
+ 2.880000000000e-07 1.805077253565e-02
+ 2.890000000000e-07 1.811175175087e-02
+ 2.900000000000e-07 1.817273096609e-02
+ 2.910000000000e-07 1.823371018130e-02
+ 2.920000000000e-07 1.829468939652e-02
+ 2.930000000000e-07 1.835566861174e-02
+ 2.940000000000e-07 1.841664782695e-02
+ 2.950000000000e-07 1.847762704217e-02
+ 2.960000000000e-07 1.853860625739e-02
+ 2.970000000000e-07 1.859958547260e-02
+ 2.980000000000e-07 1.866056468782e-02
+ 2.990000000000e-07 1.872154390304e-02
+ 3.000000000000e-07 1.878252311825e-02
+ 3.010000000000e-07 1.884350233347e-02
+ 3.020000000000e-07 1.890448154869e-02
+ 3.030000000000e-07 1.896546076390e-02
+ 3.040000000000e-07 1.902643997912e-02
+ 3.050000000000e-07 1.908741919434e-02
+ 3.060000000000e-07 1.914839840955e-02
+ 3.070000000000e-07 1.920937762477e-02
+ 3.080000000000e-07 1.927035683999e-02
+ 3.090000000000e-07 1.933133605520e-02
+ 3.100000000000e-07 1.939231527042e-02
+ 3.110000000000e-07 1.945329448564e-02
+ 3.120000000000e-07 1.951427370085e-02
+ 3.130000000000e-07 1.957525291607e-02
+ 3.140000000000e-07 1.963623213129e-02
+ 3.150000000000e-07 1.969721134650e-02
+ 3.160000000000e-07 1.975819056172e-02
+ 3.170000000000e-07 1.981916977693e-02
+ 3.180000000000e-07 1.988014899215e-02
+ 3.190000000000e-07 1.994112820737e-02
+ 3.200000000000e-07 2.000210742258e-02
+ 3.210000000000e-07 2.006308663780e-02
+ 3.220000000000e-07 2.012406585302e-02
+ 3.230000000000e-07 2.018504506823e-02
+ 3.240000000000e-07 2.024602428345e-02
+ 3.250000000000e-07 2.030700349867e-02
+ 3.260000000000e-07 2.036798271388e-02
+ 3.270000000000e-07 2.042896192910e-02
+ 3.280000000000e-07 2.048994114432e-02
+ 3.290000000000e-07 2.055092035953e-02
+ 3.300000000000e-07 2.061189957475e-02
+ 3.310000000000e-07 2.067287878997e-02
+ 3.320000000000e-07 2.073385800518e-02
+ 3.330000000000e-07 2.079483722040e-02
+ 3.340000000000e-07 2.085581643562e-02
+ 3.350000000000e-07 2.091679565083e-02
+ 3.360000000000e-07 2.097777486605e-02
+ 3.370000000000e-07 2.103875408127e-02
+ 3.380000000000e-07 2.109973329648e-02
+ 3.390000000000e-07 2.116071251170e-02
+ 3.400000000000e-07 2.122169172692e-02
+ 3.410000000000e-07 2.128267094213e-02
+ 3.420000000000e-07 2.134365015735e-02
+ 3.430000000000e-07 2.140462937257e-02
+ 3.440000000000e-07 2.146560858778e-02
+ 3.450000000000e-07 2.152658780300e-02
+ 3.460000000000e-07 2.158756701822e-02
+ 3.470000000000e-07 2.164854623343e-02
+ 3.480000000000e-07 2.170952544865e-02
+ 3.490000000000e-07 2.177050466387e-02
+ 3.500000000000e-07 2.183148387908e-02
+ 3.510000000000e-07 2.189246309430e-02
+ 3.520000000000e-07 2.195344230952e-02
+ 3.530000000000e-07 2.201442152473e-02
+ 3.540000000000e-07 2.207540073995e-02
+ 3.550000000000e-07 2.213637995517e-02
+ 3.560000000000e-07 2.219735917038e-02
+ 3.570000000000e-07 2.225833838560e-02
+ 3.580000000000e-07 2.231931760082e-02
+ 3.590000000000e-07 2.238029681603e-02
+ 3.600000000000e-07 2.244127603125e-02
+ 3.610000000000e-07 2.250225524646e-02
+ 3.620000000000e-07 2.256323446168e-02
+ 3.630000000000e-07 2.262421367690e-02
+ 3.640000000000e-07 2.268519289211e-02
+ 3.650000000000e-07 2.274617210733e-02
+ 3.660000000000e-07 2.280715132255e-02
+ 3.670000000000e-07 2.286813053776e-02
+ 3.680000000000e-07 2.292910975298e-02
+ 3.690000000000e-07 2.299008896820e-02
+ 3.700000000000e-07 2.305106818341e-02
+ 3.710000000000e-07 2.311204739863e-02
+ 3.720000000000e-07 2.317302661385e-02
+ 3.730000000000e-07 2.323400582906e-02
+ 3.740000000000e-07 2.329498504428e-02
+ 3.750000000000e-07 2.335596425950e-02
+ 3.760000000000e-07 2.341694347471e-02
+ 3.770000000000e-07 2.347792268993e-02
+ 3.780000000000e-07 2.353890190515e-02
+ 3.790000000000e-07 2.359988112036e-02
+ 3.800000000000e-07 2.366086033558e-02
+ 3.810000000000e-07 2.372183955080e-02
+ 3.820000000000e-07 2.378281876601e-02
+ 3.830000000000e-07 2.384379798123e-02
+ 3.840000000000e-07 2.390477719645e-02
+ 3.850000000000e-07 2.396575641166e-02
+ 3.860000000000e-07 2.402673562688e-02
+ 3.870000000000e-07 2.408771484210e-02
+ 3.880000000000e-07 2.414869405731e-02
+ 3.890000000000e-07 2.420967327253e-02
+ 3.900000000000e-07 2.427065248775e-02
+ 3.910000000000e-07 2.433163170296e-02
+ 3.920000000000e-07 2.439261091818e-02
+ 3.930000000000e-07 2.445359013340e-02
+ 3.940000000000e-07 2.451456934861e-02
+ 3.950000000000e-07 2.457554856383e-02
+ 3.960000000000e-07 2.463652777905e-02
+ 3.970000000000e-07 2.469750699426e-02
+ 3.980000000000e-07 2.475848620948e-02
+ 3.990000000000e-07 2.481946542470e-02
+ 4.000000000000e-07 2.488044463991e-02
+ 4.010000000000e-07 2.494142385513e-02
+ 4.020000000000e-07 2.500240307035e-02
+ 4.030000000000e-07 2.506338228556e-02
+ 4.040000000000e-07 2.512436150078e-02
+ 4.050000000000e-07 2.518534071600e-02
+ 4.060000000000e-07 2.524631993121e-02
+ 4.070000000000e-07 2.530729914643e-02
+ 4.080000000000e-07 2.536827836164e-02
+ 4.090000000000e-07 2.542925757686e-02
+ 4.100000000000e-07 2.549023679208e-02
+ 4.110000000000e-07 2.555121600729e-02
+ 4.120000000000e-07 2.561219522251e-02
+ 4.130000000000e-07 2.567317443773e-02
+ 4.140000000000e-07 2.573415365294e-02
+ 4.150000000000e-07 2.579513286816e-02
+ 4.160000000000e-07 2.585611208338e-02
+ 4.170000000000e-07 2.591709129859e-02
+ 4.180000000000e-07 2.597807051381e-02
+ 4.190000000000e-07 2.603904972903e-02
+ 4.200000000000e-07 2.610002894424e-02
+ 4.210000000000e-07 2.616100815946e-02
+ 4.220000000000e-07 2.622198737468e-02
+ 4.230000000000e-07 2.628296658989e-02
+ 4.240000000000e-07 2.634394580511e-02
+ 4.250000000000e-07 2.640492502033e-02
+ 4.260000000000e-07 2.646590423554e-02
+ 4.270000000000e-07 2.652688345076e-02
+ 4.280000000000e-07 2.658786266598e-02
+ 4.290000000000e-07 2.664884188119e-02
+ 4.300000000000e-07 2.670982109641e-02
+ 4.310000000000e-07 2.677080031163e-02
+ 4.320000000000e-07 2.683177952684e-02
+ 4.330000000000e-07 2.689275874206e-02
+ 4.340000000000e-07 2.695373795728e-02
+ 4.350000000000e-07 2.701471717249e-02
+ 4.360000000000e-07 2.707569638771e-02
+ 4.370000000000e-07 2.713667560293e-02
+ 4.380000000000e-07 2.719765481814e-02
+ 4.390000000000e-07 2.725863403336e-02
+ 4.400000000000e-07 2.731961324858e-02
+ 4.410000000000e-07 2.738059246379e-02
+ 4.420000000000e-07 2.744157167901e-02
+ 4.430000000000e-07 2.750255089423e-02
+ 4.440000000000e-07 2.756353010944e-02
+ 4.450000000000e-07 2.762450932466e-02
+ 4.460000000000e-07 2.768548853988e-02
+ 4.470000000000e-07 2.774646775509e-02
+ 4.480000000000e-07 2.780744697031e-02
+ 4.490000000000e-07 2.786842618553e-02
+ 4.500000000000e-07 2.792940540074e-02
+ 4.510000000000e-07 2.799038461596e-02
+ 4.520000000000e-07 2.805136383117e-02
+ 4.530000000000e-07 2.811234304639e-02
+ 4.540000000000e-07 2.817332226161e-02
+ 4.550000000000e-07 2.823430147682e-02
+ 4.560000000000e-07 2.829528069204e-02
+ 4.570000000000e-07 2.835625990726e-02
+ 4.580000000000e-07 2.841723912247e-02
+ 4.590000000000e-07 2.847821833769e-02
+ 4.600000000000e-07 2.853919755291e-02
+ 4.610000000000e-07 2.860017676812e-02
+ 4.620000000000e-07 2.866115598334e-02
+ 4.630000000000e-07 2.872213519856e-02
+ 4.640000000000e-07 2.878311441377e-02
+ 4.650000000000e-07 2.884409362899e-02
+ 4.660000000000e-07 2.890507284421e-02
+ 4.670000000000e-07 2.896605205942e-02
+ 4.680000000000e-07 2.902703127464e-02
+ 4.690000000000e-07 2.908801048986e-02
+ 4.700000000000e-07 2.914898970507e-02
+ 4.710000000000e-07 2.920996892029e-02
+ 4.720000000000e-07 2.927094813551e-02
+ 4.730000000000e-07 2.933192735072e-02
+ 4.740000000000e-07 2.939290656594e-02
+ 4.750000000000e-07 2.945388578116e-02
+ 4.760000000000e-07 2.951486499637e-02
+ 4.770000000000e-07 2.957584421159e-02
+ 4.780000000000e-07 2.963682342681e-02
+ 4.790000000000e-07 2.969780264202e-02
+ 4.800000000000e-07 2.975878185724e-02
+ 4.810000000000e-07 2.981976107246e-02
+ 4.820000000000e-07 2.988074028767e-02
+ 4.830000000000e-07 2.994171950289e-02
+ 4.840000000000e-07 3.000269871811e-02
+ 4.850000000000e-07 3.006367793332e-02
+ 4.860000000000e-07 3.012465714854e-02
+ 4.870000000000e-07 3.018563636376e-02
+ 4.880000000000e-07 3.024661557897e-02
+ 4.890000000000e-07 3.030759479419e-02
+ 4.900000000000e-07 3.036857400941e-02
+ 4.910000000000e-07 3.042955322462e-02
+ 4.920000000000e-07 3.049053243984e-02
+ 4.930000000000e-07 3.055151165506e-02
+ 4.940000000000e-07 3.061249087027e-02
+ 4.950000000000e-07 3.067347008549e-02
+ 4.960000000000e-07 3.073444930071e-02
+ 4.970000000000e-07 3.079542851592e-02
+ 4.980000000000e-07 3.085640773114e-02
+ 4.990000000000e-07 3.091738694635e-02
+ 5.000000000000e-07 3.097836616157e-02
+ 5.010000000000e-07 3.103934537679e-02
+ 5.020000000000e-07 3.110032459200e-02
+ 5.030000000000e-07 3.116130380722e-02
+ 5.040000000000e-07 3.122228302244e-02
+ 5.050000000000e-07 3.128326223765e-02
+ 5.060000000000e-07 3.134424145287e-02
+ 5.070000000000e-07 3.140522066809e-02
+ 5.080000000000e-07 3.146619988330e-02
+ 5.090000000000e-07 3.152717909852e-02
+ 5.100000000000e-07 3.158815831374e-02
+ 5.110000000000e-07 3.164913752895e-02
+ 5.120000000000e-07 3.171011674417e-02
+ 5.130000000000e-07 3.177109595939e-02
+ 5.140000000000e-07 3.183207517460e-02
+ 5.150000000000e-07 3.189305438982e-02
+ 5.160000000000e-07 3.195403360504e-02
+ 5.170000000000e-07 3.201501282025e-02
+ 5.180000000000e-07 3.207599203547e-02
+ 5.190000000000e-07 3.213697125069e-02
+ 5.200000000000e-07 3.219795046590e-02
+ 5.210000000000e-07 3.225892968112e-02
+ 5.220000000000e-07 3.231990889634e-02
+ 5.230000000000e-07 3.238088811155e-02
+ 5.240000000000e-07 3.244186732677e-02
+ 5.250000000000e-07 3.250284654199e-02
+ 5.260000000000e-07 3.256382575720e-02
+ 5.270000000000e-07 3.262480497242e-02
+ 5.280000000000e-07 3.268578418764e-02
+ 5.290000000000e-07 3.274676340285e-02
+ 5.300000000000e-07 3.280774261807e-02
+ 5.310000000000e-07 3.286872183329e-02
+ 5.320000000000e-07 3.292970104850e-02
+ 5.330000000000e-07 3.299068026372e-02
+ 5.340000000000e-07 3.305165947894e-02
+ 5.350000000000e-07 3.311263869415e-02
+ 5.360000000000e-07 3.317361790937e-02
+ 5.370000000000e-07 3.323459712459e-02
+ 5.380000000000e-07 3.329557633980e-02
+ 5.390000000000e-07 3.335655555502e-02
+ 5.400000000000e-07 3.341753477024e-02
+ 5.410000000000e-07 3.347851398545e-02
+ 5.420000000000e-07 3.353949320067e-02
+ 5.430000000000e-07 3.360047241588e-02
+ 5.440000000000e-07 3.366145163110e-02
+ 5.450000000000e-07 3.372243084632e-02
+ 5.460000000000e-07 3.378341006153e-02
+ 5.470000000000e-07 3.384438927675e-02
+ 5.480000000000e-07 3.390536849197e-02
+ 5.490000000000e-07 3.396634770718e-02
+ 5.500000000000e-07 3.402732692240e-02
+ 5.510000000000e-07 3.408830613762e-02
+ 5.520000000000e-07 3.414928535283e-02
+ 5.530000000000e-07 3.421026456805e-02
+ 5.540000000000e-07 3.427124378327e-02
+ 5.550000000000e-07 3.433222299848e-02
+ 5.560000000000e-07 3.439320221370e-02
+ 5.570000000000e-07 3.445418142892e-02
+ 5.580000000000e-07 3.451516064413e-02
+ 5.590000000000e-07 3.457613985935e-02
+ 5.600000000000e-07 3.463711907457e-02
+ 5.610000000000e-07 3.469809828978e-02
+ 5.620000000000e-07 3.475907750500e-02
+ 5.630000000000e-07 3.482005672022e-02
+ 5.640000000000e-07 3.488103593543e-02
+ 5.650000000000e-07 3.494201515065e-02
+ 5.660000000000e-07 3.500299436587e-02
+ 5.670000000000e-07 3.506397358108e-02
+ 5.680000000000e-07 3.512495279630e-02
+ 5.690000000000e-07 3.518593201152e-02
+ 5.700000000000e-07 3.524691122673e-02
+ 5.710000000000e-07 3.530789044195e-02
+ 5.720000000000e-07 3.536886965717e-02
+ 5.730000000000e-07 3.542984887238e-02
+ 5.740000000000e-07 3.549082808760e-02
+ 5.750000000000e-07 3.555180730282e-02
+ 5.760000000000e-07 3.561278651803e-02
+ 5.770000000000e-07 3.567376573325e-02
+ 5.780000000000e-07 3.573474494847e-02
+ 5.790000000000e-07 3.579572416368e-02
+ 5.800000000000e-07 3.585670337890e-02
+ 5.810000000000e-07 3.591768259412e-02
+ 5.820000000000e-07 3.597866180933e-02
+ 5.830000000000e-07 3.603964102455e-02
+ 5.840000000000e-07 3.610062023977e-02
+ 5.850000000000e-07 3.616159945498e-02
+ 5.860000000000e-07 3.622257867020e-02
+ 5.870000000000e-07 3.628355788542e-02
+ 5.880000000000e-07 3.634453710063e-02
+ 5.890000000000e-07 3.640551631585e-02
+ 5.900000000000e-07 3.646649553106e-02
+ 5.910000000000e-07 3.652747474628e-02
+ 5.920000000000e-07 3.658845396150e-02
+ 5.930000000000e-07 3.664943317671e-02
+ 5.940000000000e-07 3.671041239193e-02
+ 5.950000000000e-07 3.677139160715e-02
+ 5.960000000000e-07 3.683237082236e-02
+ 5.970000000000e-07 3.689335003758e-02
+ 5.980000000000e-07 3.695432925280e-02
+ 5.990000000000e-07 3.701530846801e-02
+ 6.000000000000e-07 3.707628768323e-02
+ 6.010000000000e-07 3.713726689845e-02
+ 6.020000000000e-07 3.719824611366e-02
+ 6.030000000000e-07 3.725922532888e-02
+ 6.040000000000e-07 3.732020454410e-02
+ 6.050000000000e-07 3.738118375931e-02
+ 6.060000000000e-07 3.744216297453e-02
+ 6.070000000000e-07 3.750314218975e-02
+ 6.080000000000e-07 3.756412140496e-02
+ 6.090000000000e-07 3.762510062018e-02
+ 6.100000000000e-07 3.768607983540e-02
+ 6.110000000000e-07 3.774705905061e-02
+ 6.120000000000e-07 3.780803826583e-02
+ 6.130000000000e-07 3.786901748105e-02
+ 6.140000000000e-07 3.792999669626e-02
+ 6.150000000000e-07 3.799097591148e-02
+ 6.160000000000e-07 3.805195512670e-02
+ 6.170000000000e-07 3.811293434191e-02
+ 6.180000000000e-07 3.817391355713e-02
+ 6.190000000000e-07 3.823489277235e-02
+ 6.200000000000e-07 3.829587198756e-02
+ 6.210000000000e-07 3.835685120278e-02
+ 6.220000000000e-07 3.841783041800e-02
+ 6.230000000000e-07 3.847880963321e-02
+ 6.240000000000e-07 3.853978884843e-02
+ 6.250000000000e-07 3.860076806365e-02
+ 6.260000000000e-07 3.866174727886e-02
+ 6.270000000000e-07 3.872272649408e-02
+ 6.280000000000e-07 3.878370570930e-02
+ 6.290000000000e-07 3.884468492451e-02
+ 6.300000000000e-07 3.890566413973e-02
+ 6.310000000000e-07 3.896664335495e-02
+ 6.320000000000e-07 3.902762257016e-02
+ 6.330000000000e-07 3.908860178538e-02
+ 6.340000000000e-07 3.914958100059e-02
+ 6.350000000000e-07 3.921056021581e-02
+ 6.360000000000e-07 3.927153943103e-02
+ 6.370000000000e-07 3.933251864624e-02
+ 6.380000000000e-07 3.939349786146e-02
+ 6.390000000000e-07 3.945447707668e-02
+ 6.400000000000e-07 3.951545629189e-02
+ 6.410000000000e-07 3.957643550711e-02
+ 6.420000000000e-07 3.963741472233e-02
+ 6.430000000000e-07 3.969839393754e-02
+ 6.440000000000e-07 3.975937315276e-02
+ 6.450000000000e-07 3.982035236798e-02
+ 6.460000000000e-07 3.988133158319e-02
+ 6.470000000000e-07 3.994231079841e-02
+ 6.480000000000e-07 4.000329001363e-02
+ 6.490000000000e-07 4.006426922884e-02
+ 6.500000000000e-07 4.012524844406e-02
+ 6.510000000000e-07 4.018622765928e-02
+ 6.520000000000e-07 4.024720687449e-02
+ 6.530000000000e-07 4.030818608971e-02
+ 6.540000000000e-07 4.036916530493e-02
+ 6.550000000000e-07 4.043014452014e-02
+ 6.560000000000e-07 4.049112373536e-02
+ 6.570000000000e-07 4.055210295058e-02
+ 6.580000000000e-07 4.061308216579e-02
+ 6.590000000000e-07 4.067406138101e-02
+ 6.600000000000e-07 4.073504059623e-02
+ 6.610000000000e-07 4.079601981144e-02
+ 6.620000000000e-07 4.085699902666e-02
+ 6.630000000000e-07 4.091797824188e-02
+ 6.640000000000e-07 4.097895745709e-02
+ 6.650000000000e-07 4.103993667231e-02
+ 6.660000000000e-07 4.110091588753e-02
+ 6.670000000000e-07 4.116189510274e-02
+ 6.680000000000e-07 4.122287431796e-02
+ 6.690000000000e-07 4.128385353318e-02
+ 6.700000000000e-07 4.134483274839e-02
+ 6.710000000000e-07 4.140581196361e-02
+ 6.720000000000e-07 4.146679117883e-02
+ 6.730000000000e-07 4.152777039404e-02
+ 6.740000000000e-07 4.158874960926e-02
+ 6.750000000000e-07 4.164972882448e-02
+ 6.760000000000e-07 4.171070803969e-02
+ 6.770000000000e-07 4.177168725491e-02
+ 6.780000000000e-07 4.183266647013e-02
+ 6.790000000000e-07 4.189364568534e-02
+ 6.800000000000e-07 4.195462490056e-02
+ 6.810000000000e-07 4.201560411577e-02
+ 6.820000000000e-07 4.207658333099e-02
+ 6.830000000000e-07 4.213756254621e-02
+ 6.840000000000e-07 4.219854176142e-02
+ 6.850000000000e-07 4.225952097664e-02
+ 6.860000000000e-07 4.232050019186e-02
+ 6.870000000000e-07 4.238147940707e-02
+ 6.880000000000e-07 4.244245862229e-02
+ 6.890000000000e-07 4.250343783751e-02
+ 6.900000000000e-07 4.256441705272e-02
+ 6.910000000000e-07 4.262539626794e-02
+ 6.920000000000e-07 4.268637548316e-02
+ 6.930000000000e-07 4.274735469837e-02
+ 6.940000000000e-07 4.280833391359e-02
+ 6.950000000000e-07 4.286931312881e-02
+ 6.960000000000e-07 4.293029234402e-02
+ 6.970000000000e-07 4.299127155924e-02
+ 6.980000000000e-07 4.305225077446e-02
+ 6.990000000000e-07 4.311322998967e-02
+ 7.000000000000e-07 4.317420920489e-02
+ 7.010000000000e-07 4.323518842011e-02
+ 7.020000000000e-07 4.329616763532e-02
+ 7.030000000000e-07 4.335714685054e-02
+ 7.040000000000e-07 4.341812606576e-02
+ 7.050000000000e-07 4.347910528097e-02
+ 7.060000000000e-07 4.354008449619e-02
+ 7.070000000000e-07 4.360106371141e-02
+ 7.080000000000e-07 4.366204292662e-02
+ 7.090000000000e-07 4.372302214184e-02
+ 7.100000000000e-07 4.378400135706e-02
+ 7.110000000000e-07 4.384498057227e-02
+ 7.120000000000e-07 4.390595978749e-02
+ 7.130000000000e-07 4.396693900271e-02
+ 7.140000000000e-07 4.402791821792e-02
+ 7.150000000000e-07 4.408889743314e-02
+ 7.160000000000e-07 4.414987664836e-02
+ 7.170000000000e-07 4.421085586357e-02
+ 7.180000000000e-07 4.427183507879e-02
+ 7.190000000000e-07 4.433281429401e-02
+ 7.200000000000e-07 4.439379350922e-02
+ 7.210000000000e-07 4.445477272444e-02
+ 7.220000000000e-07 4.451575193966e-02
+ 7.230000000000e-07 4.457673115487e-02
+ 7.240000000000e-07 4.463771037009e-02
+ 7.250000000000e-07 4.469868958530e-02
+ 7.260000000000e-07 4.475966880052e-02
+ 7.270000000000e-07 4.482064801574e-02
+ 7.280000000000e-07 4.488162723095e-02
+ 7.290000000000e-07 4.494260644617e-02
+ 7.300000000000e-07 4.500358566139e-02
+ 7.310000000000e-07 4.506456487660e-02
+ 7.320000000000e-07 4.512554409182e-02
+ 7.330000000000e-07 4.518652330704e-02
+ 7.340000000000e-07 4.524750252225e-02
+ 7.350000000000e-07 4.530848173747e-02
+ 7.360000000000e-07 4.536946095269e-02
+ 7.370000000000e-07 4.543044016790e-02
+ 7.380000000000e-07 4.549141938312e-02
+ 7.390000000000e-07 4.555239859834e-02
+ 7.400000000000e-07 4.561337781355e-02
+ 7.410000000000e-07 4.567435702877e-02
+ 7.420000000000e-07 4.573533624399e-02
+ 7.430000000000e-07 4.579631545920e-02
+ 7.440000000000e-07 4.585729467442e-02
+ 7.450000000000e-07 4.591827388964e-02
+ 7.460000000000e-07 4.597925310485e-02
+ 7.470000000000e-07 4.604023232007e-02
+ 7.480000000000e-07 4.610121153529e-02
+ 7.490000000000e-07 4.616219075050e-02
+ 7.500000000000e-07 4.622316996572e-02
+ 7.510000000000e-07 4.628414918094e-02
+ 7.520000000000e-07 4.634512839615e-02
+ 7.530000000000e-07 4.640610761137e-02
+ 7.540000000000e-07 4.646708682659e-02
+ 7.550000000000e-07 4.652806604180e-02
+ 7.560000000000e-07 4.658904525702e-02
+ 7.570000000000e-07 4.665002447224e-02
+ 7.580000000000e-07 4.671100368745e-02
+ 7.590000000000e-07 4.677198290267e-02
+ 7.600000000000e-07 4.683296211789e-02
+ 7.610000000000e-07 4.689394133310e-02
+ 7.620000000000e-07 4.695492054832e-02
+ 7.630000000000e-07 4.701589976354e-02
+ 7.640000000000e-07 4.707687897875e-02
+ 7.650000000000e-07 4.713785819397e-02
+ 7.660000000000e-07 4.719883740919e-02
+ 7.670000000000e-07 4.725981662440e-02
+ 7.680000000000e-07 4.732079583962e-02
+ 7.690000000000e-07 4.738177505484e-02
+ 7.700000000000e-07 4.744275427005e-02
+ 7.710000000000e-07 4.750373348527e-02
+ 7.720000000000e-07 4.756471270048e-02
+ 7.730000000000e-07 4.762569191570e-02
+ 7.740000000000e-07 4.768667113092e-02
+ 7.750000000000e-07 4.774765034613e-02
+ 7.760000000000e-07 4.780862956135e-02
+ 7.770000000000e-07 4.786960877657e-02
+ 7.780000000000e-07 4.793058799178e-02
+ 7.790000000000e-07 4.799156720700e-02
+ 7.800000000000e-07 4.805254642222e-02
+ 7.810000000000e-07 4.811352563743e-02
+ 7.820000000000e-07 4.817450485265e-02
+ 7.830000000000e-07 4.823548406787e-02
+ 7.840000000000e-07 4.829646328308e-02
+ 7.850000000000e-07 4.835744249830e-02
+ 7.860000000000e-07 4.841842171352e-02
+ 7.870000000000e-07 4.847940092873e-02
+ 7.880000000000e-07 4.854038014395e-02
+ 7.890000000000e-07 4.860135935917e-02
+ 7.900000000000e-07 4.866233857438e-02
+ 7.910000000000e-07 4.872331778960e-02
+ 7.920000000000e-07 4.878429700482e-02
+ 7.930000000000e-07 4.884527622003e-02
+ 7.940000000000e-07 4.890625543525e-02
+ 7.950000000000e-07 4.896723465047e-02
+ 7.960000000000e-07 4.902821386568e-02
+ 7.970000000000e-07 4.908919308090e-02
+ 7.980000000000e-07 4.915017229612e-02
+ 7.990000000000e-07 4.921115151133e-02
+ 8.000000000000e-07 4.927213072655e-02
+ 8.010000000000e-07 4.933310994177e-02
+ 8.020000000000e-07 4.939408915698e-02
+ 8.030000000000e-07 4.945506837220e-02
+ 8.040000000000e-07 4.951604758742e-02
+ 8.050000000000e-07 4.957702680263e-02
+ 8.060000000000e-07 4.963800601785e-02
+ 8.070000000000e-07 4.969898523307e-02
+ 8.080000000000e-07 4.975996444828e-02
+ 8.090000000000e-07 4.982094366350e-02
+ 8.100000000000e-07 4.988192287872e-02
+ 8.110000000000e-07 4.994290209393e-02
+ 8.120000000000e-07 5.000388130915e-02
+ 8.130000000000e-07 5.006486052437e-02
+ 8.140000000000e-07 5.012583973958e-02
+ 8.150000000000e-07 5.018681895480e-02
+ 8.160000000000e-07 5.024779817001e-02
+ 8.170000000000e-07 5.030877738523e-02
+ 8.180000000000e-07 5.036975660045e-02
+ 8.190000000000e-07 5.043073581566e-02
+ 8.200000000000e-07 5.049171503088e-02
+ 8.210000000000e-07 5.055269424610e-02
+ 8.220000000000e-07 5.061367346131e-02
+ 8.230000000000e-07 5.067465267653e-02
+ 8.240000000000e-07 5.073563189175e-02
+ 8.250000000000e-07 5.079661110696e-02
+ 8.260000000000e-07 5.085759032218e-02
+ 8.270000000000e-07 5.091856953740e-02
+ 8.280000000000e-07 5.097954875261e-02
+ 8.290000000000e-07 5.104052796783e-02
+ 8.300000000000e-07 5.110150718305e-02
+ 8.310000000000e-07 5.116248639826e-02
+ 8.320000000000e-07 5.122346561348e-02
+ 8.330000000000e-07 5.128444482870e-02
+ 8.340000000000e-07 5.134542404391e-02
+ 8.350000000000e-07 5.140640325913e-02
+ 8.360000000000e-07 5.146738247435e-02
+ 8.370000000000e-07 5.152836168956e-02
+ 8.380000000000e-07 5.158934090478e-02
+ 8.390000000000e-07 5.165032012000e-02
+ 8.400000000000e-07 5.171129933521e-02
+ 8.410000000000e-07 5.177227855043e-02
+ 8.420000000000e-07 5.183325776565e-02
+ 8.430000000000e-07 5.189423698086e-02
+ 8.440000000000e-07 5.195521619608e-02
+ 8.450000000000e-07 5.201619541130e-02
+ 8.460000000000e-07 5.207717462651e-02
+ 8.470000000000e-07 5.213815384173e-02
+ 8.480000000000e-07 5.219913305695e-02
+ 8.490000000000e-07 5.226011227216e-02
+ 8.500000000000e-07 5.232109148738e-02
+ 8.510000000000e-07 5.238207070260e-02
+ 8.520000000000e-07 5.244304991781e-02
+ 8.530000000000e-07 5.250402913303e-02
+ 8.540000000000e-07 5.256500834825e-02
+ 8.550000000000e-07 5.262598756346e-02
+ 8.560000000000e-07 5.268696677868e-02
+ 8.570000000000e-07 5.274794599390e-02
+ 8.580000000000e-07 5.280892520911e-02
+ 8.590000000000e-07 5.286990442433e-02
+ 8.600000000000e-07 5.293088363955e-02
+ 8.610000000000e-07 5.299186285476e-02
+ 8.620000000000e-07 5.305284206998e-02
+ 8.630000000000e-07 5.311382128519e-02
+ 8.640000000000e-07 5.317480050041e-02
+ 8.650000000000e-07 5.323577971563e-02
+ 8.660000000000e-07 5.329675893084e-02
+ 8.670000000000e-07 5.335773814606e-02
+ 8.680000000000e-07 5.341871736128e-02
+ 8.690000000000e-07 5.347969657649e-02
+ 8.700000000000e-07 5.354067579171e-02
+ 8.710000000000e-07 5.360165500693e-02
+ 8.720000000000e-07 5.366263422214e-02
+ 8.730000000000e-07 5.372361343736e-02
+ 8.740000000000e-07 5.378459265258e-02
+ 8.750000000000e-07 5.384557186779e-02
+ 8.760000000000e-07 5.390655108301e-02
+ 8.770000000000e-07 5.396753029823e-02
+ 8.780000000000e-07 5.402850951344e-02
+ 8.790000000000e-07 5.408948872866e-02
+ 8.800000000000e-07 5.415046794388e-02
+ 8.810000000000e-07 5.421144715909e-02
+ 8.820000000000e-07 5.427242637431e-02
+ 8.830000000000e-07 5.433340558953e-02
+ 8.840000000000e-07 5.439438480474e-02
+ 8.850000000000e-07 5.445536401996e-02
+ 8.860000000000e-07 5.451634323518e-02
+ 8.870000000000e-07 5.457732245039e-02
+ 8.880000000000e-07 5.463830166561e-02
+ 8.890000000000e-07 5.469928088083e-02
+ 8.900000000000e-07 5.476026009604e-02
+ 8.910000000000e-07 5.482123931126e-02
+ 8.920000000000e-07 5.488221852648e-02
+ 8.930000000000e-07 5.494319774169e-02
+ 8.940000000000e-07 5.500417695691e-02
+ 8.950000000000e-07 5.506515617213e-02
+ 8.960000000000e-07 5.512613538734e-02
+ 8.970000000000e-07 5.518711460256e-02
+ 8.980000000000e-07 5.524809381778e-02
+ 8.990000000000e-07 5.530907303299e-02
+ 9.000000000000e-07 5.537005224821e-02
+ 9.010000000000e-07 5.543103146343e-02
+ 9.020000000000e-07 5.549201067864e-02
+ 9.030000000000e-07 5.555298989386e-02
+ 9.040000000000e-07 5.561396910908e-02
+ 9.050000000000e-07 5.567494832429e-02
+ 9.060000000000e-07 5.573592753951e-02
+ 9.070000000000e-07 5.579690675472e-02
+ 9.080000000000e-07 5.585788596994e-02
+ 9.090000000000e-07 5.591886518516e-02
+ 9.100000000000e-07 5.597984440037e-02
+ 9.110000000000e-07 5.604082361559e-02
+ 9.120000000000e-07 5.610180283081e-02
+ 9.130000000000e-07 5.616278204602e-02
+ 9.140000000000e-07 5.622376126124e-02
+ 9.150000000000e-07 5.628474047646e-02
+ 9.160000000000e-07 5.634571969167e-02
+ 9.170000000000e-07 5.640669890689e-02
+ 9.180000000000e-07 5.646767812211e-02
+ 9.190000000000e-07 5.652865733732e-02
+ 9.200000000000e-07 5.658963655254e-02
+ 9.210000000000e-07 5.665061576776e-02
+ 9.220000000000e-07 5.671159498297e-02
+ 9.230000000000e-07 5.677257419819e-02
+ 9.240000000000e-07 5.683355341341e-02
+ 9.250000000000e-07 5.689453262862e-02
+ 9.260000000000e-07 5.695551184384e-02
+ 9.270000000000e-07 5.701649105906e-02
+ 9.280000000000e-07 5.707747027427e-02
+ 9.290000000000e-07 5.713844948949e-02
+ 9.300000000000e-07 5.719942870471e-02
+ 9.310000000000e-07 5.726040791992e-02
+ 9.320000000000e-07 5.732138713514e-02
+ 9.330000000000e-07 5.738236635036e-02
+ 9.340000000000e-07 5.744334556557e-02
+ 9.350000000000e-07 5.750432478079e-02
+ 9.360000000000e-07 5.756530399601e-02
+ 9.370000000000e-07 5.762628321122e-02
+ 9.380000000000e-07 5.768726242644e-02
+ 9.390000000000e-07 5.774824164166e-02
+ 9.400000000000e-07 5.780922085687e-02
+ 9.410000000000e-07 5.787020007209e-02
+ 9.420000000000e-07 5.793117928731e-02
+ 9.430000000000e-07 5.799215850252e-02
+ 9.440000000000e-07 5.805313771774e-02
+ 9.450000000000e-07 5.811411693296e-02
+ 9.460000000000e-07 5.817509614817e-02
+ 9.470000000000e-07 5.823607536339e-02
+ 9.480000000000e-07 5.829705457861e-02
+ 9.490000000000e-07 5.835803379382e-02
+ 9.500000000000e-07 5.841901300904e-02
+ 9.510000000000e-07 5.847999222426e-02
+ 9.520000000000e-07 5.854097143947e-02
+ 9.530000000000e-07 5.860195065469e-02
+ 9.540000000000e-07 5.866292986990e-02
+ 9.550000000000e-07 5.872390908512e-02
+ 9.560000000000e-07 5.878488830034e-02
+ 9.570000000000e-07 5.884586751555e-02
+ 9.580000000000e-07 5.890684673077e-02
+ 9.590000000000e-07 5.896782594599e-02
+ 9.600000000000e-07 5.902880516120e-02
+ 9.610000000000e-07 5.908978437642e-02
+ 9.620000000000e-07 5.915076359164e-02
+ 9.630000000000e-07 5.921174280685e-02
+ 9.640000000000e-07 5.927272202207e-02
+ 9.650000000000e-07 5.933370123729e-02
+ 9.660000000000e-07 5.939468045250e-02
+ 9.670000000000e-07 5.945565966772e-02
+ 9.680000000000e-07 5.951663888294e-02
+ 9.690000000000e-07 5.957761809815e-02
+ 9.700000000000e-07 5.963859731337e-02
+ 9.710000000000e-07 5.969957652859e-02
+ 9.720000000000e-07 5.976055574380e-02
+ 9.730000000000e-07 5.982153495902e-02
+ 9.740000000000e-07 5.988251417424e-02
+ 9.750000000000e-07 5.994349338945e-02
+ 9.760000000000e-07 6.000447260467e-02
+ 9.770000000000e-07 6.006545181989e-02
+ 9.780000000000e-07 6.012643103510e-02
+ 9.790000000000e-07 6.018741025032e-02
+ 9.800000000000e-07 6.024838946554e-02
+ 9.810000000000e-07 6.030936868075e-02
+ 9.820000000000e-07 6.037034789597e-02
+ 9.830000000000e-07 6.043132711119e-02
+ 9.840000000000e-07 6.049230632640e-02
+ 9.850000000000e-07 6.055328554162e-02
+ 9.860000000000e-07 6.061426475684e-02
+ 9.870000000000e-07 6.067524397205e-02
+ 9.880000000000e-07 6.073622318727e-02
+ 9.890000000000e-07 6.079720240249e-02
+ 9.900000000000e-07 6.085818161770e-02
+ 9.910000000000e-07 6.091916083292e-02
+ 9.920000000000e-07 6.098014004814e-02
+ 9.930000000000e-07 6.104111926335e-02
+ 9.940000000000e-07 6.110209847857e-02
+ 9.950000000000e-07 6.116307769379e-02
+ 9.960000000000e-07 6.122405690900e-02
+ 9.970000000000e-07 6.128503612422e-02
+ 9.980000000000e-07 6.134601533943e-02
+ 9.990000000000e-07 6.140699455465e-02
+ 1.000000000000e-06 6.146797376987e-02
+ 1.001000000000e-06 6.152895298508e-02
+ 1.002000000000e-06 6.158993220030e-02
+ 1.003000000000e-06 6.165091141552e-02
+ 1.004000000000e-06 6.171189063073e-02
+ 1.005000000000e-06 6.177286984595e-02
+ 1.006000000000e-06 6.183384906117e-02
+ 1.007000000000e-06 6.189482827638e-02
+ 1.008000000000e-06 6.195580749160e-02
+ 1.009000000000e-06 6.201678670682e-02
+ 1.010000000000e-06 6.207776592203e-02
+ 1.011000000000e-06 6.213874513725e-02
+ 1.012000000000e-06 6.219972435247e-02
+ 1.013000000000e-06 6.226070356768e-02
+ 1.014000000000e-06 6.232168278290e-02
+ 1.015000000000e-06 6.238266199812e-02
+ 1.016000000000e-06 6.244364121333e-02
+ 1.017000000000e-06 6.250462042855e-02
+ 1.018000000000e-06 6.256559964377e-02
+ 1.019000000000e-06 6.262657885898e-02
+ 1.020000000000e-06 6.268755807420e-02
+ 1.021000000000e-06 6.274853728942e-02
+ 1.022000000000e-06 6.280951650463e-02
+ 1.023000000000e-06 6.287049571985e-02
+ 1.024000000000e-06 6.293147493507e-02
+ 1.025000000000e-06 6.299245415028e-02
+ 1.026000000000e-06 6.305343336550e-02
+ 1.027000000000e-06 6.311441258072e-02
+ 1.028000000000e-06 6.317539179593e-02
+ 1.029000000000e-06 6.323637101115e-02
+ 1.030000000000e-06 6.329735022637e-02
+ 1.031000000000e-06 6.335832944158e-02
+ 1.032000000000e-06 6.341930865680e-02
+ 1.033000000000e-06 6.348028787202e-02
+ 1.034000000000e-06 6.354126708723e-02
+ 1.035000000000e-06 6.360224630245e-02
+ 1.036000000000e-06 6.366322551767e-02
+ 1.037000000000e-06 6.372420473288e-02
+ 1.038000000000e-06 6.378518394810e-02
+ 1.039000000000e-06 6.384616316332e-02
+ 1.040000000000e-06 6.390714237853e-02
+ 1.041000000000e-06 6.396812159375e-02
+ 1.042000000000e-06 6.402910080897e-02
+ 1.043000000000e-06 6.409008002418e-02
+ 1.044000000000e-06 6.415105923940e-02
+ 1.045000000000e-06 6.421203845461e-02
+ 1.046000000000e-06 6.427301766983e-02
+ 1.047000000000e-06 6.433399688505e-02
+ 1.048000000000e-06 6.439497610026e-02
+ 1.049000000000e-06 6.445595531548e-02
+ 1.050000000000e-06 6.451693453070e-02
+ 1.051000000000e-06 6.457791374591e-02
+ 1.052000000000e-06 6.463889296113e-02
+ 1.053000000000e-06 6.469987217635e-02
+ 1.054000000000e-06 6.476085139156e-02
+ 1.055000000000e-06 6.482183060678e-02
+ 1.056000000000e-06 6.488280982200e-02
+ 1.057000000000e-06 6.494378903721e-02
+ 1.058000000000e-06 6.500476825243e-02
+ 1.059000000000e-06 6.506574746765e-02
+ 1.060000000000e-06 6.512672668286e-02
+ 1.061000000000e-06 6.518770589808e-02
+ 1.062000000000e-06 6.524868511330e-02
+ 1.063000000000e-06 6.530966432851e-02
+ 1.064000000000e-06 6.537064354373e-02
+ 1.065000000000e-06 6.543162275895e-02
+ 1.066000000000e-06 6.549260197416e-02
+ 1.067000000000e-06 6.555358118938e-02
+ 1.068000000000e-06 6.561456040460e-02
+ 1.069000000000e-06 6.567553961981e-02
+ 1.070000000000e-06 6.573651883503e-02
+ 1.071000000000e-06 6.579749805025e-02
+ 1.072000000000e-06 6.585847726546e-02
+ 1.073000000000e-06 6.591945648068e-02
+ 1.074000000000e-06 6.598043569590e-02
+ 1.075000000000e-06 6.604141491111e-02
+ 1.076000000000e-06 6.610239412633e-02
+ 1.077000000000e-06 6.616337334155e-02
+ 1.078000000000e-06 6.622435255676e-02
+ 1.079000000000e-06 6.628533177198e-02
+ 1.080000000000e-06 6.634631098720e-02
+ 1.081000000000e-06 6.640729020241e-02
+ 1.082000000000e-06 6.646826941763e-02
+ 1.083000000000e-06 6.652924863285e-02
+ 1.084000000000e-06 6.659022784806e-02
+ 1.085000000000e-06 6.665120706328e-02
+ 1.086000000000e-06 6.671218627850e-02
+ 1.087000000000e-06 6.677316549371e-02
+ 1.088000000000e-06 6.683414470893e-02
+ 1.089000000000e-06 6.689512392414e-02
+ 1.090000000000e-06 6.695610313936e-02
+ 1.091000000000e-06 6.701708235458e-02
+ 1.092000000000e-06 6.707806156979e-02
+ 1.093000000000e-06 6.713904078501e-02
+ 1.094000000000e-06 6.720002000023e-02
+ 1.095000000000e-06 6.726099921544e-02
+ 1.096000000000e-06 6.732197843066e-02
+ 1.097000000000e-06 6.738295764588e-02
+ 1.098000000000e-06 6.744393686109e-02
+ 1.099000000000e-06 6.750491607631e-02
+ 1.100000000000e-06 6.756589529153e-02
+ 1.101000000000e-06 6.762687450674e-02
+ 1.102000000000e-06 6.768785372196e-02
+ 1.103000000000e-06 6.774883293718e-02
+ 1.104000000000e-06 6.780981215239e-02
+ 1.105000000000e-06 6.787079136761e-02
+ 1.106000000000e-06 6.793177058283e-02
+ 1.107000000000e-06 6.799274979804e-02
+ 1.108000000000e-06 6.805372901326e-02
+ 1.109000000000e-06 6.811470822848e-02
+ 1.110000000000e-06 6.817568744369e-02
+ 1.111000000000e-06 6.823666665891e-02
+ 1.112000000000e-06 6.829764587413e-02
+ 1.113000000000e-06 6.835862508934e-02
+ 1.114000000000e-06 6.841960430456e-02
+ 1.115000000000e-06 6.848058351978e-02
+ 1.116000000000e-06 6.854156273499e-02
+ 1.117000000000e-06 6.860254195021e-02
+ 1.118000000000e-06 6.866352116543e-02
+ 1.119000000000e-06 6.872450038064e-02
+ 1.120000000000e-06 6.878547959586e-02
+ 1.121000000000e-06 6.884645881108e-02
+ 1.122000000000e-06 6.890743802629e-02
+ 1.123000000000e-06 6.896841724151e-02
+ 1.124000000000e-06 6.902939645673e-02
+ 1.125000000000e-06 6.909037567194e-02
+ 1.126000000000e-06 6.915135488716e-02
+ 1.127000000000e-06 6.921233410238e-02
+ 1.128000000000e-06 6.927331331759e-02
+ 1.129000000000e-06 6.933429253281e-02
+ 1.130000000000e-06 6.939527174803e-02
+ 1.131000000000e-06 6.945625096324e-02
+ 1.132000000000e-06 6.951723017846e-02
+ 1.133000000000e-06 6.957820939368e-02
+ 1.134000000000e-06 6.963918860889e-02
+ 1.135000000000e-06 6.970016782411e-02
+ 1.136000000000e-06 6.976114703932e-02
+ 1.137000000000e-06 6.982212625454e-02
+ 1.138000000000e-06 6.988310546976e-02
+ 1.139000000000e-06 6.994408468497e-02
+ 1.140000000000e-06 7.000506390019e-02
+ 1.141000000000e-06 7.006604311541e-02
+ 1.142000000000e-06 7.012702233062e-02
+ 1.143000000000e-06 7.018800154584e-02
+ 1.144000000000e-06 7.024898076106e-02
+ 1.145000000000e-06 7.030995997627e-02
+ 1.146000000000e-06 7.037093919149e-02
+ 1.147000000000e-06 7.043191840671e-02
+ 1.148000000000e-06 7.049289762192e-02
+ 1.149000000000e-06 7.055387683714e-02
+ 1.150000000000e-06 7.061485605236e-02
+ 1.151000000000e-06 7.067583526757e-02
+ 1.152000000000e-06 7.073681448279e-02
+ 1.153000000000e-06 7.079779369801e-02
+ 1.154000000000e-06 7.085877291322e-02
+ 1.155000000000e-06 7.091975212844e-02
+ 1.156000000000e-06 7.098073134366e-02
+ 1.157000000000e-06 7.104171055887e-02
+ 1.158000000000e-06 7.110268977409e-02
+ 1.159000000000e-06 7.116366898931e-02
+ 1.160000000000e-06 7.122464820452e-02
+ 1.161000000000e-06 7.128562741974e-02
+ 1.162000000000e-06 7.134660663496e-02
+ 1.163000000000e-06 7.140758585017e-02
+ 1.164000000000e-06 7.146856506539e-02
+ 1.165000000000e-06 7.152954428061e-02
+ 1.166000000000e-06 7.159052349582e-02
+ 1.167000000000e-06 7.165150271104e-02
+ 1.168000000000e-06 7.171248192626e-02
+ 1.169000000000e-06 7.177346114147e-02
+ 1.170000000000e-06 7.183444035669e-02
+ 1.171000000000e-06 7.189541957191e-02
+ 1.172000000000e-06 7.195639878712e-02
+ 1.173000000000e-06 7.201737800234e-02
+ 1.174000000000e-06 7.207835721756e-02
+ 1.175000000000e-06 7.213933643277e-02
+ 1.176000000000e-06 7.220031564799e-02
+ 1.177000000000e-06 7.226129486321e-02
+ 1.178000000000e-06 7.232227407842e-02
+ 1.179000000000e-06 7.238325329364e-02
+ 1.180000000000e-06 7.244423250885e-02
+ 1.181000000000e-06 7.250521172407e-02
+ 1.182000000000e-06 7.256619093929e-02
+ 1.183000000000e-06 7.262717015450e-02
+ 1.184000000000e-06 7.268814936972e-02
+ 1.185000000000e-06 7.274912858494e-02
+ 1.186000000000e-06 7.281010780015e-02
+ 1.187000000000e-06 7.287108701537e-02
+ 1.188000000000e-06 7.293206623059e-02
+ 1.189000000000e-06 7.299304544580e-02
+ 1.190000000000e-06 7.305402466102e-02
+ 1.191000000000e-06 7.311500387624e-02
+ 1.192000000000e-06 7.317598309145e-02
+ 1.193000000000e-06 7.323696230667e-02
+ 1.194000000000e-06 7.329794152189e-02
+ 1.195000000000e-06 7.335892073710e-02
+ 1.196000000000e-06 7.341989995232e-02
+ 1.197000000000e-06 7.348087916754e-02
+ 1.198000000000e-06 7.354185838275e-02
+ 1.199000000000e-06 7.360283759797e-02
+ 1.200000000000e-06 7.366381681319e-02
+ 1.201000000000e-06 7.372479602840e-02
+ 1.202000000000e-06 7.378577524362e-02
+ 1.203000000000e-06 7.384675445884e-02
+ 1.204000000000e-06 7.390773367405e-02
+ 1.205000000000e-06 7.396871288927e-02
+ 1.206000000000e-06 7.402969210449e-02
+ 1.207000000000e-06 7.409067131970e-02
+ 1.208000000000e-06 7.415165053492e-02
+ 1.209000000000e-06 7.421262975014e-02
+ 1.210000000000e-06 7.427360896535e-02
+ 1.211000000000e-06 7.433458818057e-02
+ 1.212000000000e-06 7.439556739579e-02
+ 1.213000000000e-06 7.445654661100e-02
+ 1.214000000000e-06 7.451752582622e-02
+ 1.215000000000e-06 7.457850504144e-02
+ 1.216000000000e-06 7.463948425665e-02
+ 1.217000000000e-06 7.470046347187e-02
+ 1.218000000000e-06 7.476144268709e-02
+ 1.219000000000e-06 7.482242190230e-02
+ 1.220000000000e-06 7.488340111752e-02
+ 1.221000000000e-06 7.494438033274e-02
+ 1.222000000000e-06 7.500535954795e-02
+ 1.223000000000e-06 7.506633876317e-02
+ 1.224000000000e-06 7.512731797839e-02
+ 1.225000000000e-06 7.518829719360e-02
+ 1.226000000000e-06 7.524927640882e-02
+ 1.227000000000e-06 7.531025562403e-02
+ 1.228000000000e-06 7.537123483925e-02
+ 1.229000000000e-06 7.543221405447e-02
+ 1.230000000000e-06 7.549319326968e-02
+ 1.231000000000e-06 7.555417248490e-02
+ 1.232000000000e-06 7.561515170012e-02
+ 1.233000000000e-06 7.567613091533e-02
+ 1.234000000000e-06 7.573711013055e-02
+ 1.235000000000e-06 7.579808934577e-02
+ 1.236000000000e-06 7.585906856098e-02
+ 1.237000000000e-06 7.592004777620e-02
+ 1.238000000000e-06 7.598102699142e-02
+ 1.239000000000e-06 7.604200620663e-02
+ 1.240000000000e-06 7.610298542185e-02
+ 1.241000000000e-06 7.616396463707e-02
+ 1.242000000000e-06 7.622494385228e-02
+ 1.243000000000e-06 7.628592306750e-02
+ 1.244000000000e-06 7.634690228272e-02
+ 1.245000000000e-06 7.640788149793e-02
+ 1.246000000000e-06 7.646886071315e-02
+ 1.247000000000e-06 7.652983992837e-02
+ 1.248000000000e-06 7.659081914358e-02
+ 1.249000000000e-06 7.665179835880e-02
+ 1.250000000000e-06 7.671277757402e-02
+ 1.251000000000e-06 7.677375678923e-02
+ 1.252000000000e-06 7.683473600445e-02
+ 1.253000000000e-06 7.689571521967e-02
+ 1.254000000000e-06 7.695669443488e-02
+ 1.255000000000e-06 7.701767365010e-02
+ 1.256000000000e-06 7.707865286532e-02
+ 1.257000000000e-06 7.713963208053e-02
+ 1.258000000000e-06 7.720061129575e-02
+ 1.259000000000e-06 7.726159051097e-02
+ 1.260000000000e-06 7.732256972618e-02
+ 1.261000000000e-06 7.738354894140e-02
+ 1.262000000000e-06 7.744452815662e-02
+ 1.263000000000e-06 7.750550737183e-02
+ 1.264000000000e-06 7.756648658705e-02
+ 1.265000000000e-06 7.762746580227e-02
+ 1.266000000000e-06 7.768844501748e-02
+ 1.267000000000e-06 7.774942423270e-02
+ 1.268000000000e-06 7.781040344792e-02
+ 1.269000000000e-06 7.787138266313e-02
+ 1.270000000000e-06 7.793236187835e-02
+ 1.271000000000e-06 7.799334109356e-02
+ 1.272000000000e-06 7.805432030878e-02
+ 1.273000000000e-06 7.811529952400e-02
+ 1.274000000000e-06 7.817627873921e-02
+ 1.275000000000e-06 7.823725795443e-02
+ 1.276000000000e-06 7.829823716965e-02
+ 1.277000000000e-06 7.835921638486e-02
+ 1.278000000000e-06 7.842019560008e-02
+ 1.279000000000e-06 7.848117481530e-02
+ 1.280000000000e-06 7.854215403051e-02
+ 1.281000000000e-06 7.860313324573e-02
+ 1.282000000000e-06 7.866411246095e-02
+ 1.283000000000e-06 7.872509167616e-02
+ 1.284000000000e-06 7.878607089138e-02
+ 1.285000000000e-06 7.884705010660e-02
+ 1.286000000000e-06 7.890802932181e-02
+ 1.287000000000e-06 7.896900853703e-02
+ 1.288000000000e-06 7.902998775225e-02
+ 1.289000000000e-06 7.909096696746e-02
+ 1.290000000000e-06 7.915194618268e-02
+ 1.291000000000e-06 7.921292539790e-02
+ 1.292000000000e-06 7.927390461311e-02
+ 1.293000000000e-06 7.933488382833e-02
+ 1.294000000000e-06 7.939586304355e-02
+ 1.295000000000e-06 7.945684225876e-02
+ 1.296000000000e-06 7.951782147398e-02
+ 1.297000000000e-06 7.957880068920e-02
+ 1.298000000000e-06 7.963977990441e-02
+ 1.299000000000e-06 7.970075911963e-02
+ 1.300000000000e-06 7.976173833485e-02
+ 1.301000000000e-06 7.982271755006e-02
+ 1.302000000000e-06 7.988369676528e-02
+ 1.303000000000e-06 7.994467598050e-02
+ 1.304000000000e-06 8.000565519571e-02
+ 1.305000000000e-06 8.006663441093e-02
+ 1.306000000000e-06 8.012761362615e-02
+ 1.307000000000e-06 8.018859284136e-02
+ 1.308000000000e-06 8.024957205658e-02
+ 1.309000000000e-06 8.031055127180e-02
+ 1.310000000000e-06 8.037153048701e-02
+ 1.311000000000e-06 8.043250970223e-02
+ 1.312000000000e-06 8.049348891745e-02
+ 1.313000000000e-06 8.055446813266e-02
+ 1.314000000000e-06 8.061544734788e-02
+ 1.315000000000e-06 8.067642656310e-02
+ 1.316000000000e-06 8.073740577831e-02
+ 1.317000000000e-06 8.079838499353e-02
+ 1.318000000000e-06 8.085936420874e-02
+ 1.319000000000e-06 8.092034342396e-02
+ 1.320000000000e-06 8.098132263918e-02
+ 1.321000000000e-06 8.104230185439e-02
+ 1.322000000000e-06 8.110328106961e-02
+ 1.323000000000e-06 8.116426028483e-02
+ 1.324000000000e-06 8.122523950004e-02
+ 1.325000000000e-06 8.128621871526e-02
+ 1.326000000000e-06 8.134719793048e-02
+ 1.327000000000e-06 8.140817714569e-02
+ 1.328000000000e-06 8.146915636091e-02
+ 1.329000000000e-06 8.153013557613e-02
+ 1.330000000000e-06 8.159111479134e-02
+ 1.331000000000e-06 8.165209400656e-02
+ 1.332000000000e-06 8.171307322178e-02
+ 1.333000000000e-06 8.177405243699e-02
+ 1.334000000000e-06 8.183503165221e-02
+ 1.335000000000e-06 8.189601086743e-02
+ 1.336000000000e-06 8.195699008264e-02
+ 1.337000000000e-06 8.201796929786e-02
+ 1.338000000000e-06 8.207894851308e-02
+ 1.339000000000e-06 8.213992772829e-02
+ 1.340000000000e-06 8.220090694351e-02
+ 1.341000000000e-06 8.226188615873e-02
+ 1.342000000000e-06 8.232286537394e-02
+ 1.343000000000e-06 8.238384458916e-02
+ 1.344000000000e-06 8.244482380438e-02
+ 1.345000000000e-06 8.250580301959e-02
+ 1.346000000000e-06 8.256678223481e-02
+ 1.347000000000e-06 8.262776145003e-02
+ 1.348000000000e-06 8.268874066524e-02
+ 1.349000000000e-06 8.274971988046e-02
+ 1.350000000000e-06 8.281069909568e-02
+ 1.351000000000e-06 8.287167831089e-02
+ 1.352000000000e-06 8.293265752611e-02
+ 1.353000000000e-06 8.299363674133e-02
+ 1.354000000000e-06 8.305461595654e-02
+ 1.355000000000e-06 8.311559517176e-02
+ 1.356000000000e-06 8.317657438698e-02
+ 1.357000000000e-06 8.323755360219e-02
+ 1.358000000000e-06 8.329853281741e-02
+ 1.359000000000e-06 8.335951203263e-02
+ 1.360000000000e-06 8.342049124784e-02
+ 1.361000000000e-06 8.348147046306e-02
+ 1.362000000000e-06 8.354244967827e-02
+ 1.363000000000e-06 8.360342889349e-02
+ 1.364000000000e-06 8.366440810871e-02
+ 1.365000000000e-06 8.372538732392e-02
+ 1.366000000000e-06 8.378636653914e-02
+ 1.367000000000e-06 8.384734575436e-02
+ 1.368000000000e-06 8.390832496957e-02
+ 1.369000000000e-06 8.396930418479e-02
+ 1.370000000000e-06 8.403028340001e-02
+ 1.371000000000e-06 8.409126261522e-02
+ 1.372000000000e-06 8.415224183044e-02
+ 1.373000000000e-06 8.421322104566e-02
+ 1.374000000000e-06 8.427420026087e-02
+ 1.375000000000e-06 8.433517947609e-02
+ 1.376000000000e-06 8.439615869131e-02
+ 1.377000000000e-06 8.445713790652e-02
+ 1.378000000000e-06 8.451811712174e-02
+ 1.379000000000e-06 8.457909633696e-02
+ 1.380000000000e-06 8.464007555217e-02
+ 1.381000000000e-06 8.470105476739e-02
+ 1.382000000000e-06 8.476203398261e-02
+ 1.383000000000e-06 8.482301319782e-02
+ 1.384000000000e-06 8.488399241304e-02
+ 1.385000000000e-06 8.494497162826e-02
+ 1.386000000000e-06 8.500595084347e-02
+ 1.387000000000e-06 8.506693005869e-02
+ 1.388000000000e-06 8.512790927391e-02
+ 1.389000000000e-06 8.518888848912e-02
+ 1.390000000000e-06 8.524986770434e-02
+ 1.391000000000e-06 8.531084691956e-02
+ 1.392000000000e-06 8.537182613477e-02
+ 1.393000000000e-06 8.543280534999e-02
+ 1.394000000000e-06 8.549378456521e-02
+ 1.395000000000e-06 8.555476378042e-02
+ 1.396000000000e-06 8.561574299564e-02
+ 1.397000000000e-06 8.567672221086e-02
+ 1.398000000000e-06 8.573770142607e-02
+ 1.399000000000e-06 8.579868064129e-02
+ 1.400000000000e-06 8.585965985651e-02
+ 1.401000000000e-06 8.592063907172e-02
+ 1.402000000000e-06 8.598161828694e-02
+ 1.403000000000e-06 8.604259750216e-02
+ 1.404000000000e-06 8.610357671737e-02
+ 1.405000000000e-06 8.616455593259e-02
+ 1.406000000000e-06 8.622553514781e-02
+ 1.407000000000e-06 8.628651436302e-02
+ 1.408000000000e-06 8.634749357824e-02
+ 1.409000000000e-06 8.640847279345e-02
+ 1.410000000000e-06 8.646945200867e-02
+ 1.411000000000e-06 8.653043122389e-02
+ 1.412000000000e-06 8.659141043910e-02
+ 1.413000000000e-06 8.665238965432e-02
+ 1.414000000000e-06 8.671336886954e-02
+ 1.415000000000e-06 8.677434808475e-02
+ 1.416000000000e-06 8.683532729997e-02
+ 1.417000000000e-06 8.689630651519e-02
+ 1.418000000000e-06 8.695728573040e-02
+ 1.419000000000e-06 8.701826494562e-02
+ 1.420000000000e-06 8.707924416084e-02
+ 1.421000000000e-06 8.714022337605e-02
+ 1.422000000000e-06 8.720120259127e-02
+ 1.423000000000e-06 8.726218180649e-02
+ 1.424000000000e-06 8.732316102170e-02
+ 1.425000000000e-06 8.738414023692e-02
+ 1.426000000000e-06 8.744511945214e-02
+ 1.427000000000e-06 8.750609866735e-02
+ 1.428000000000e-06 8.756707788257e-02
+ 1.429000000000e-06 8.762805709779e-02
+ 1.430000000000e-06 8.768903631300e-02
+ 1.431000000000e-06 8.775001552822e-02
+ 1.432000000000e-06 8.781099474344e-02
+ 1.433000000000e-06 8.787197395865e-02
+ 1.434000000000e-06 8.793295317387e-02
+ 1.435000000000e-06 8.799393238909e-02
+ 1.436000000000e-06 8.805491160430e-02
+ 1.437000000000e-06 8.811589081952e-02
+ 1.438000000000e-06 8.817687003474e-02
+ 1.439000000000e-06 8.823784924995e-02
+ 1.440000000000e-06 8.829882846517e-02
+ 1.441000000000e-06 8.835980768039e-02
+ 1.442000000000e-06 8.842078689560e-02
+ 1.443000000000e-06 8.848176611082e-02
+ 1.444000000000e-06 8.854274532604e-02
+ 1.445000000000e-06 8.860372454125e-02
+ 1.446000000000e-06 8.866470375647e-02
+ 1.447000000000e-06 8.872568297169e-02
+ 1.448000000000e-06 8.878666218690e-02
+ 1.449000000000e-06 8.884764140212e-02
+ 1.450000000000e-06 8.890862061734e-02
+ 1.451000000000e-06 8.896959983255e-02
+ 1.452000000000e-06 8.903057904777e-02
+ 1.453000000000e-06 8.909155826298e-02
+ 1.454000000000e-06 8.915253747820e-02
+ 1.455000000000e-06 8.921351669342e-02
+ 1.456000000000e-06 8.927449590863e-02
+ 1.457000000000e-06 8.933547512385e-02
+ 1.458000000000e-06 8.939645433907e-02
+ 1.459000000000e-06 8.945743355428e-02
+ 1.460000000000e-06 8.951841276950e-02
+ 1.461000000000e-06 8.957939198472e-02
+ 1.462000000000e-06 8.964037119993e-02
+ 1.463000000000e-06 8.970135041515e-02
+ 1.464000000000e-06 8.976232963037e-02
+ 1.465000000000e-06 8.982330884558e-02
+ 1.466000000000e-06 8.988428806080e-02
+ 1.467000000000e-06 8.994526727602e-02
+ 1.468000000000e-06 9.000624649123e-02
+ 1.469000000000e-06 9.006722570645e-02
+ 1.470000000000e-06 9.012820492167e-02
+ 1.471000000000e-06 9.018918413688e-02
+ 1.472000000000e-06 9.025016335210e-02
+ 1.473000000000e-06 9.031114256732e-02
+ 1.474000000000e-06 9.037212178253e-02
+ 1.475000000000e-06 9.043310099775e-02
+ 1.476000000000e-06 9.049408021297e-02
+ 1.477000000000e-06 9.055505942818e-02
+ 1.478000000000e-06 9.061603864340e-02
+ 1.479000000000e-06 9.067701785862e-02
+ 1.480000000000e-06 9.073799707383e-02
+ 1.481000000000e-06 9.079897628905e-02
+ 1.482000000000e-06 9.085995550427e-02
+ 1.483000000000e-06 9.092093471948e-02
+ 1.484000000000e-06 9.098191393470e-02
+ 1.485000000000e-06 9.104289314992e-02
+ 1.486000000000e-06 9.110387236513e-02
+ 1.487000000000e-06 9.116485158035e-02
+ 1.488000000000e-06 9.122583079557e-02
+ 1.489000000000e-06 9.128681001078e-02
+ 1.490000000000e-06 9.134778922600e-02
+ 1.491000000000e-06 9.140876844122e-02
+ 1.492000000000e-06 9.146974765643e-02
+ 1.493000000000e-06 9.153072687165e-02
+ 1.494000000000e-06 9.159170608687e-02
+ 1.495000000000e-06 9.165268530208e-02
+ 1.496000000000e-06 9.171366451730e-02
+ 1.497000000000e-06 9.177464373252e-02
+ 1.498000000000e-06 9.183562294773e-02
+ 1.499000000000e-06 9.189660216295e-02
+ 1.500000000000e-06 9.195758137816e-02
+ 1.501000000000e-06 9.201856059338e-02
+ 1.502000000000e-06 9.207953980860e-02
+ 1.503000000000e-06 9.214051902381e-02
+ 1.504000000000e-06 9.220149823903e-02
+ 1.505000000000e-06 9.226247745425e-02
+ 1.506000000000e-06 9.232345666946e-02
+ 1.507000000000e-06 9.238443588468e-02
+ 1.508000000000e-06 9.244541509990e-02
+ 1.509000000000e-06 9.250639431511e-02
+ 1.510000000000e-06 9.256737353033e-02
+ 1.511000000000e-06 9.262835274555e-02
+ 1.512000000000e-06 9.268933196076e-02
+ 1.513000000000e-06 9.275031117598e-02
+ 1.514000000000e-06 9.281129039120e-02
+ 1.515000000000e-06 9.287226960641e-02
+ 1.516000000000e-06 9.293324882163e-02
+ 1.517000000000e-06 9.299422803685e-02
+ 1.518000000000e-06 9.305520725206e-02
+ 1.519000000000e-06 9.311618646728e-02
+ 1.520000000000e-06 9.317716568250e-02
+ 1.521000000000e-06 9.323814489771e-02
+ 1.522000000000e-06 9.329912411293e-02
+ 1.523000000000e-06 9.336010332815e-02
+ 1.524000000000e-06 9.342108254336e-02
+ 1.525000000000e-06 9.348206175858e-02
+ 1.526000000000e-06 9.354304097380e-02
+ 1.527000000000e-06 9.360402018901e-02
+ 1.528000000000e-06 9.366499940423e-02
+ 1.529000000000e-06 9.372597861945e-02
+ 1.530000000000e-06 9.378695783466e-02
+ 1.531000000000e-06 9.384793704988e-02
+ 1.532000000000e-06 9.390891626510e-02
+ 1.533000000000e-06 9.396989548031e-02
+ 1.534000000000e-06 9.403087469553e-02
+ 1.535000000000e-06 9.409185391075e-02
+ 1.536000000000e-06 9.415283312596e-02
+ 1.537000000000e-06 9.421381234118e-02
+ 1.538000000000e-06 9.427479155640e-02
+ 1.539000000000e-06 9.433577077161e-02
+ 1.540000000000e-06 9.439674998683e-02
+ 1.541000000000e-06 9.445772920205e-02
+ 1.542000000000e-06 9.451870841726e-02
+ 1.543000000000e-06 9.457968763248e-02
+ 1.544000000000e-06 9.464066684769e-02
+ 1.545000000000e-06 9.470164606291e-02
+ 1.546000000000e-06 9.476262527813e-02
+ 1.547000000000e-06 9.482360449334e-02
+ 1.548000000000e-06 9.488458370856e-02
+ 1.549000000000e-06 9.494556292378e-02
+ 1.550000000000e-06 9.500654213899e-02
+ 1.551000000000e-06 9.506752135421e-02
+ 1.552000000000e-06 9.512850056943e-02
+ 1.553000000000e-06 9.518947978464e-02
+ 1.554000000000e-06 9.525045899986e-02
+ 1.555000000000e-06 9.531143821508e-02
+ 1.556000000000e-06 9.537241743029e-02
+ 1.557000000000e-06 9.543339664551e-02
+ 1.558000000000e-06 9.549437586073e-02
+ 1.559000000000e-06 9.555535507594e-02
+ 1.560000000000e-06 9.561633429116e-02
+ 1.561000000000e-06 9.567731350638e-02
+ 1.562000000000e-06 9.573829272159e-02
+ 1.563000000000e-06 9.579927193681e-02
+ 1.564000000000e-06 9.586025115203e-02
+ 1.565000000000e-06 9.592123036724e-02
+ 1.566000000000e-06 9.598220958246e-02
+ 1.567000000000e-06 9.604318879768e-02
+ 1.568000000000e-06 9.610416801289e-02
+ 1.569000000000e-06 9.616514722811e-02
+ 1.570000000000e-06 9.622612644333e-02
+ 1.571000000000e-06 9.628710565854e-02
+ 1.572000000000e-06 9.634808487376e-02
+ 1.573000000000e-06 9.640906408898e-02
+ 1.574000000000e-06 9.647004330419e-02
+ 1.575000000000e-06 9.653102251941e-02
+ 1.576000000000e-06 9.659200173463e-02
+ 1.577000000000e-06 9.665298094984e-02
+ 1.578000000000e-06 9.671396016506e-02
+ 1.579000000000e-06 9.677493938028e-02
+ 1.580000000000e-06 9.683591859549e-02
+ 1.581000000000e-06 9.689689781071e-02
+ 1.582000000000e-06 9.695787702593e-02
+ 1.583000000000e-06 9.701885624114e-02
+ 1.584000000000e-06 9.707983545636e-02
+ 1.585000000000e-06 9.714081467158e-02
+ 1.586000000000e-06 9.720179388679e-02
+ 1.587000000000e-06 9.726277310201e-02
+ 1.588000000000e-06 9.732375231723e-02
+ 1.589000000000e-06 9.738473153244e-02
+ 1.590000000000e-06 9.744571074766e-02
+ 1.591000000000e-06 9.750668996287e-02
+ 1.592000000000e-06 9.756766917809e-02
+ 1.593000000000e-06 9.762864839331e-02
+ 1.594000000000e-06 9.768962760852e-02
+ 1.595000000000e-06 9.775060682374e-02
+ 1.596000000000e-06 9.781158603896e-02
+ 1.597000000000e-06 9.787256525417e-02
+ 1.598000000000e-06 9.793354446939e-02
+ 1.599000000000e-06 9.799452368461e-02
+ 1.600000000000e-06 9.805550289982e-02
+ 1.601000000000e-06 9.811648211504e-02
+ 1.602000000000e-06 9.817746133026e-02
+ 1.603000000000e-06 9.823844054547e-02
+ 1.604000000000e-06 9.829941976069e-02
+ 1.605000000000e-06 9.836039897591e-02
+ 1.606000000000e-06 9.842137819112e-02
+ 1.607000000000e-06 9.848235740634e-02
+ 1.608000000000e-06 9.854333662156e-02
+ 1.609000000000e-06 9.860431583677e-02
+ 1.610000000000e-06 9.866529505199e-02
+ 1.611000000000e-06 9.872627426721e-02
+ 1.612000000000e-06 9.878725348242e-02
+ 1.613000000000e-06 9.884823269764e-02
+ 1.614000000000e-06 9.890921191286e-02
+ 1.615000000000e-06 9.897019112807e-02
+ 1.616000000000e-06 9.903117034329e-02
+ 1.617000000000e-06 9.909214955851e-02
+ 1.618000000000e-06 9.915312877372e-02
+ 1.619000000000e-06 9.921410798894e-02
+ 1.620000000000e-06 9.927508720416e-02
+ 1.621000000000e-06 9.933606641937e-02
+ 1.622000000000e-06 9.939704563459e-02
+ 1.623000000000e-06 9.945802484981e-02
+ 1.624000000000e-06 9.951900406502e-02
+ 1.625000000000e-06 9.957998328024e-02
+ 1.626000000000e-06 9.964096249546e-02
+ 1.627000000000e-06 9.970194171067e-02
+ 1.628000000000e-06 9.976292092589e-02
+ 1.629000000000e-06 9.982390014111e-02
+ 1.630000000000e-06 9.988487935632e-02
+ 1.631000000000e-06 9.994585857154e-02
+ 1.632000000000e-06 1.000068377868e-01
+ 1.633000000000e-06 1.000678170020e-01
+ 1.634000000000e-06 1.001287962172e-01
+ 1.635000000000e-06 1.001897754324e-01
+ 1.636000000000e-06 1.002507546476e-01
+ 1.637000000000e-06 1.003117338628e-01
+ 1.638000000000e-06 1.003727130781e-01
+ 1.639000000000e-06 1.004336922933e-01
+ 1.640000000000e-06 1.004946715085e-01
+ 1.641000000000e-06 1.005556507237e-01
+ 1.642000000000e-06 1.006166299389e-01
+ 1.643000000000e-06 1.006776091541e-01
+ 1.644000000000e-06 1.007385883694e-01
+ 1.645000000000e-06 1.007995675846e-01
+ 1.646000000000e-06 1.008605467998e-01
+ 1.647000000000e-06 1.009215260150e-01
+ 1.648000000000e-06 1.009825052302e-01
+ 1.649000000000e-06 1.010434844454e-01
+ 1.650000000000e-06 1.011044636607e-01
+ 1.651000000000e-06 1.011654428759e-01
+ 1.652000000000e-06 1.012264220911e-01
+ 1.653000000000e-06 1.012874013063e-01
+ 1.654000000000e-06 1.013483805215e-01
+ 1.655000000000e-06 1.014093597367e-01
+ 1.656000000000e-06 1.014703389520e-01
+ 1.657000000000e-06 1.015313181672e-01
+ 1.658000000000e-06 1.015922973824e-01
+ 1.659000000000e-06 1.016532765976e-01
+ 1.660000000000e-06 1.017142558128e-01
+ 1.661000000000e-06 1.017752350280e-01
+ 1.662000000000e-06 1.018362142433e-01
+ 1.663000000000e-06 1.018971934585e-01
+ 1.664000000000e-06 1.019581726737e-01
+ 1.665000000000e-06 1.020191518889e-01
+ 1.666000000000e-06 1.020801311041e-01
+ 1.667000000000e-06 1.021411103193e-01
+ 1.668000000000e-06 1.022020895346e-01
+ 1.669000000000e-06 1.022630687498e-01
+ 1.670000000000e-06 1.023240479650e-01
+ 1.671000000000e-06 1.023850271802e-01
+ 1.672000000000e-06 1.024460063954e-01
+ 1.673000000000e-06 1.025069856106e-01
+ 1.674000000000e-06 1.025679648259e-01
+ 1.675000000000e-06 1.026289440411e-01
+ 1.676000000000e-06 1.026899232563e-01
+ 1.677000000000e-06 1.027509024715e-01
+ 1.678000000000e-06 1.028118816867e-01
+ 1.679000000000e-06 1.028728609019e-01
+ 1.680000000000e-06 1.029338401172e-01
+ 1.681000000000e-06 1.029948193324e-01
+ 1.682000000000e-06 1.030557985476e-01
+ 1.683000000000e-06 1.031167777628e-01
+ 1.684000000000e-06 1.031777569780e-01
+ 1.685000000000e-06 1.032387361932e-01
+ 1.686000000000e-06 1.032997154085e-01
+ 1.687000000000e-06 1.033606946237e-01
+ 1.688000000000e-06 1.034216738389e-01
+ 1.689000000000e-06 1.034826530541e-01
+ 1.690000000000e-06 1.035436322693e-01
+ 1.691000000000e-06 1.036046114845e-01
+ 1.692000000000e-06 1.036655906998e-01
+ 1.693000000000e-06 1.037265699150e-01
+ 1.694000000000e-06 1.037875491302e-01
+ 1.695000000000e-06 1.038485283454e-01
+ 1.696000000000e-06 1.039095075606e-01
+ 1.697000000000e-06 1.039704867758e-01
+ 1.698000000000e-06 1.040314659911e-01
+ 1.699000000000e-06 1.040924452063e-01
+ 1.700000000000e-06 1.041534244215e-01
+ 1.701000000000e-06 1.042144036367e-01
+ 1.702000000000e-06 1.042753828519e-01
+ 1.703000000000e-06 1.043363620671e-01
+ 1.704000000000e-06 1.043973412823e-01
+ 1.705000000000e-06 1.044583204976e-01
+ 1.706000000000e-06 1.045192997128e-01
+ 1.707000000000e-06 1.045802789280e-01
+ 1.708000000000e-06 1.046412581432e-01
+ 1.709000000000e-06 1.047022373584e-01
+ 1.710000000000e-06 1.047632165736e-01
+ 1.711000000000e-06 1.048241957889e-01
+ 1.712000000000e-06 1.048851750041e-01
+ 1.713000000000e-06 1.049461542193e-01
+ 1.714000000000e-06 1.050071334345e-01
+ 1.715000000000e-06 1.050681126497e-01
+ 1.716000000000e-06 1.051290918649e-01
+ 1.717000000000e-06 1.051900710802e-01
+ 1.718000000000e-06 1.052510502954e-01
+ 1.719000000000e-06 1.053120295106e-01
+ 1.720000000000e-06 1.053730087258e-01
+ 1.721000000000e-06 1.054339879410e-01
+ 1.722000000000e-06 1.054949671562e-01
+ 1.723000000000e-06 1.055559463715e-01
+ 1.724000000000e-06 1.056169255867e-01
+ 1.725000000000e-06 1.056779048019e-01
+ 1.726000000000e-06 1.057388840171e-01
+ 1.727000000000e-06 1.057998632323e-01
+ 1.728000000000e-06 1.058608424475e-01
+ 1.729000000000e-06 1.059218216628e-01
+ 1.730000000000e-06 1.059828008780e-01
+ 1.731000000000e-06 1.060437800932e-01
+ 1.732000000000e-06 1.061047593084e-01
+ 1.733000000000e-06 1.061657385236e-01
+ 1.734000000000e-06 1.062267177388e-01
+ 1.735000000000e-06 1.062876969541e-01
+ 1.736000000000e-06 1.063486761693e-01
+ 1.737000000000e-06 1.064096553845e-01
+ 1.738000000000e-06 1.064706345997e-01
+ 1.739000000000e-06 1.065316138149e-01
+ 1.740000000000e-06 1.065925930301e-01
+ 1.741000000000e-06 1.066535722454e-01
+ 1.742000000000e-06 1.067145514606e-01
+ 1.743000000000e-06 1.067755306758e-01
+ 1.744000000000e-06 1.068365098910e-01
+ 1.745000000000e-06 1.068974891062e-01
+ 1.746000000000e-06 1.069584683214e-01
+ 1.747000000000e-06 1.070194475367e-01
+ 1.748000000000e-06 1.070804267519e-01
+ 1.749000000000e-06 1.071414059671e-01
+ 1.750000000000e-06 1.072023851823e-01
+ 1.751000000000e-06 1.072633643975e-01
+ 1.752000000000e-06 1.073243436127e-01
+ 1.753000000000e-06 1.073853228280e-01
+ 1.754000000000e-06 1.074463020432e-01
+ 1.755000000000e-06 1.075072812584e-01
+ 1.756000000000e-06 1.075682604736e-01
+ 1.757000000000e-06 1.076292396888e-01
+ 1.758000000000e-06 1.076902189040e-01
+ 1.759000000000e-06 1.077511981193e-01
+ 1.760000000000e-06 1.078121773345e-01
+ 1.761000000000e-06 1.078731565497e-01
+ 1.762000000000e-06 1.079341357649e-01
+ 1.763000000000e-06 1.079951149801e-01
+ 1.764000000000e-06 1.080560941953e-01
+ 1.765000000000e-06 1.081170734106e-01
+ 1.766000000000e-06 1.081780526258e-01
+ 1.767000000000e-06 1.082390318410e-01
+ 1.768000000000e-06 1.083000110562e-01
+ 1.769000000000e-06 1.083609902714e-01
+ 1.770000000000e-06 1.084219694866e-01
+ 1.771000000000e-06 1.084829487019e-01
+ 1.772000000000e-06 1.085439279171e-01
+ 1.773000000000e-06 1.086049071323e-01
+ 1.774000000000e-06 1.086658863475e-01
+ 1.775000000000e-06 1.087268655627e-01
+ 1.776000000000e-06 1.087878447779e-01
+ 1.777000000000e-06 1.088488239932e-01
+ 1.778000000000e-06 1.089098032084e-01
+ 1.779000000000e-06 1.089707824236e-01
+ 1.780000000000e-06 1.090317616388e-01
+ 1.781000000000e-06 1.090927408540e-01
+ 1.782000000000e-06 1.091537200692e-01
+ 1.783000000000e-06 1.092146992845e-01
+ 1.784000000000e-06 1.092756784997e-01
+ 1.785000000000e-06 1.093366577149e-01
+ 1.786000000000e-06 1.093976369301e-01
+ 1.787000000000e-06 1.094586161453e-01
+ 1.788000000000e-06 1.095195953605e-01
+ 1.789000000000e-06 1.095805745758e-01
+ 1.790000000000e-06 1.096415537910e-01
+ 1.791000000000e-06 1.097025330062e-01
+ 1.792000000000e-06 1.097635122214e-01
+ 1.793000000000e-06 1.098244914366e-01
+ 1.794000000000e-06 1.098854706518e-01
+ 1.795000000000e-06 1.099464498671e-01
+ 1.796000000000e-06 1.100074290823e-01
+ 1.797000000000e-06 1.100684082975e-01
+ 1.798000000000e-06 1.101293875127e-01
+ 1.799000000000e-06 1.101903667279e-01
+ 1.800000000000e-06 1.102513459431e-01
+ 1.801000000000e-06 1.103123251584e-01
+ 1.802000000000e-06 1.103733043736e-01
+ 1.803000000000e-06 1.104342835888e-01
+ 1.804000000000e-06 1.104952628040e-01
+ 1.805000000000e-06 1.105562420192e-01
+ 1.806000000000e-06 1.106172212344e-01
+ 1.807000000000e-06 1.106782004497e-01
+ 1.808000000000e-06 1.107391796649e-01
+ 1.809000000000e-06 1.108001588801e-01
+ 1.810000000000e-06 1.108611380953e-01
+ 1.811000000000e-06 1.109221173105e-01
+ 1.812000000000e-06 1.109830965257e-01
+ 1.813000000000e-06 1.110440757410e-01
+ 1.814000000000e-06 1.111050549562e-01
+ 1.815000000000e-06 1.111660341714e-01
+ 1.816000000000e-06 1.112270133866e-01
+ 1.817000000000e-06 1.112879926018e-01
+ 1.818000000000e-06 1.113489718170e-01
+ 1.819000000000e-06 1.114099510323e-01
+ 1.820000000000e-06 1.114709302475e-01
+ 1.821000000000e-06 1.115319094627e-01
+ 1.822000000000e-06 1.115928886779e-01
+ 1.823000000000e-06 1.116538678931e-01
+ 1.824000000000e-06 1.117148471083e-01
+ 1.825000000000e-06 1.117758263236e-01
+ 1.826000000000e-06 1.118368055388e-01
+ 1.827000000000e-06 1.118977847540e-01
+ 1.828000000000e-06 1.119587639692e-01
+ 1.829000000000e-06 1.120197431844e-01
+ 1.830000000000e-06 1.120807223996e-01
+ 1.831000000000e-06 1.121417016149e-01
+ 1.832000000000e-06 1.122026808301e-01
+ 1.833000000000e-06 1.122636600453e-01
+ 1.834000000000e-06 1.123246392605e-01
+ 1.835000000000e-06 1.123856184757e-01
+ 1.836000000000e-06 1.124465976909e-01
+ 1.837000000000e-06 1.125075769062e-01
+ 1.838000000000e-06 1.125685561214e-01
+ 1.839000000000e-06 1.126295353366e-01
+ 1.840000000000e-06 1.126905145518e-01
+ 1.841000000000e-06 1.127514937670e-01
+ 1.842000000000e-06 1.128124729822e-01
+ 1.843000000000e-06 1.128734521975e-01
+ 1.844000000000e-06 1.129344314127e-01
+ 1.845000000000e-06 1.129954106279e-01
+ 1.846000000000e-06 1.130563898431e-01
+ 1.847000000000e-06 1.131173690583e-01
+ 1.848000000000e-06 1.131783482735e-01
+ 1.849000000000e-06 1.132393274888e-01
+ 1.850000000000e-06 1.133003067040e-01
+ 1.851000000000e-06 1.133612859192e-01
+ 1.852000000000e-06 1.134222651344e-01
+ 1.853000000000e-06 1.134832443496e-01
+ 1.854000000000e-06 1.135442235648e-01
+ 1.855000000000e-06 1.136052027801e-01
+ 1.856000000000e-06 1.136661819953e-01
+ 1.857000000000e-06 1.137271612105e-01
+ 1.858000000000e-06 1.137881404257e-01
+ 1.859000000000e-06 1.138491196409e-01
+ 1.860000000000e-06 1.139100988561e-01
+ 1.861000000000e-06 1.139710780714e-01
+ 1.862000000000e-06 1.140320572866e-01
+ 1.863000000000e-06 1.140930365018e-01
+ 1.864000000000e-06 1.141540157170e-01
+ 1.865000000000e-06 1.142149949322e-01
+ 1.866000000000e-06 1.142759741474e-01
+ 1.867000000000e-06 1.143369533627e-01
+ 1.868000000000e-06 1.143979325779e-01
+ 1.869000000000e-06 1.144589117931e-01
+ 1.870000000000e-06 1.145198910083e-01
+ 1.871000000000e-06 1.145808702235e-01
+ 1.872000000000e-06 1.146418494387e-01
+ 1.873000000000e-06 1.147028286540e-01
+ 1.874000000000e-06 1.147638078692e-01
+ 1.875000000000e-06 1.148247870844e-01
+ 1.876000000000e-06 1.148857662996e-01
+ 1.877000000000e-06 1.149467455148e-01
+ 1.878000000000e-06 1.150077247300e-01
+ 1.879000000000e-06 1.150687039453e-01
+ 1.880000000000e-06 1.151296831605e-01
+ 1.881000000000e-06 1.151906623757e-01
+ 1.882000000000e-06 1.152516415909e-01
+ 1.883000000000e-06 1.153126208061e-01
+ 1.884000000000e-06 1.153736000213e-01
+ 1.885000000000e-06 1.154345792366e-01
+ 1.886000000000e-06 1.154955584518e-01
+ 1.887000000000e-06 1.155565376670e-01
+ 1.888000000000e-06 1.156175168822e-01
+ 1.889000000000e-06 1.156784960974e-01
+ 1.890000000000e-06 1.157394753126e-01
+ 1.891000000000e-06 1.158004545279e-01
+ 1.892000000000e-06 1.158614337431e-01
+ 1.893000000000e-06 1.159224129583e-01
+ 1.894000000000e-06 1.159833921735e-01
+ 1.895000000000e-06 1.160443713887e-01
+ 1.896000000000e-06 1.161053506039e-01
+ 1.897000000000e-06 1.161663298192e-01
+ 1.898000000000e-06 1.162273090344e-01
+ 1.899000000000e-06 1.162882882496e-01
+ 1.900000000000e-06 1.163492674648e-01
+ 1.901000000000e-06 1.164102466800e-01
+ 1.902000000000e-06 1.164712258952e-01
+ 1.903000000000e-06 1.165322051105e-01
+ 1.904000000000e-06 1.165931843257e-01
+ 1.905000000000e-06 1.166541635409e-01
+ 1.906000000000e-06 1.167151427561e-01
+ 1.907000000000e-06 1.167761219713e-01
+ 1.908000000000e-06 1.168371011865e-01
+ 1.909000000000e-06 1.168980804018e-01
+ 1.910000000000e-06 1.169590596170e-01
+ 1.911000000000e-06 1.170200388322e-01
+ 1.912000000000e-06 1.170810180474e-01
+ 1.913000000000e-06 1.171419972626e-01
+ 1.914000000000e-06 1.172029764778e-01
+ 1.915000000000e-06 1.172639556931e-01
+ 1.916000000000e-06 1.173249349083e-01
+ 1.917000000000e-06 1.173859141235e-01
+ 1.918000000000e-06 1.174468933387e-01
+ 1.919000000000e-06 1.175078725539e-01
+ 1.920000000000e-06 1.175688517691e-01
+ 1.921000000000e-06 1.176298309844e-01
+ 1.922000000000e-06 1.176908101996e-01
+ 1.923000000000e-06 1.177517894148e-01
+ 1.924000000000e-06 1.178127686300e-01
+ 1.925000000000e-06 1.178737478452e-01
+ 1.926000000000e-06 1.179347270604e-01
+ 1.927000000000e-06 1.179957062757e-01
+ 1.928000000000e-06 1.180566854909e-01
+ 1.929000000000e-06 1.181176647061e-01
+ 1.930000000000e-06 1.181786439213e-01
+ 1.931000000000e-06 1.182396231365e-01
+ 1.932000000000e-06 1.183006023517e-01
+ 1.933000000000e-06 1.183615815669e-01
+ 1.934000000000e-06 1.184225607822e-01
+ 1.935000000000e-06 1.184835399974e-01
+ 1.936000000000e-06 1.185445192126e-01
+ 1.937000000000e-06 1.186054984278e-01
+ 1.938000000000e-06 1.186664776430e-01
+ 1.939000000000e-06 1.187274568582e-01
+ 1.940000000000e-06 1.187884360735e-01
+ 1.941000000000e-06 1.188494152887e-01
+ 1.942000000000e-06 1.189103945039e-01
+ 1.943000000000e-06 1.189713737191e-01
+ 1.944000000000e-06 1.190323529343e-01
+ 1.945000000000e-06 1.190933321495e-01
+ 1.946000000000e-06 1.191543113648e-01
+ 1.947000000000e-06 1.192152905800e-01
+ 1.948000000000e-06 1.192762697952e-01
+ 1.949000000000e-06 1.193372490104e-01
+ 1.950000000000e-06 1.193982282256e-01
+ 1.951000000000e-06 1.194592074408e-01
+ 1.952000000000e-06 1.195201866561e-01
+ 1.953000000000e-06 1.195811658713e-01
+ 1.954000000000e-06 1.196421450865e-01
+ 1.955000000000e-06 1.197031243017e-01
+ 1.956000000000e-06 1.197641035169e-01
+ 1.957000000000e-06 1.198250827321e-01
+ 1.958000000000e-06 1.198860619474e-01
+ 1.959000000000e-06 1.199470411626e-01
+ 1.960000000000e-06 1.200080203778e-01
+ 1.961000000000e-06 1.200689995930e-01
+ 1.962000000000e-06 1.201299788082e-01
+ 1.963000000000e-06 1.201909580234e-01
+ 1.964000000000e-06 1.202519372387e-01
+ 1.965000000000e-06 1.203129164539e-01
+ 1.966000000000e-06 1.203738956691e-01
+ 1.967000000000e-06 1.204348748843e-01
+ 1.968000000000e-06 1.204958540995e-01
+ 1.969000000000e-06 1.205568333147e-01
+ 1.970000000000e-06 1.206178125300e-01
+ 1.971000000000e-06 1.206787917452e-01
+ 1.972000000000e-06 1.207397709604e-01
+ 1.973000000000e-06 1.208007501756e-01
+ 1.974000000000e-06 1.208617293908e-01
+ 1.975000000000e-06 1.209227086060e-01
+ 1.976000000000e-06 1.209836878213e-01
+ 1.977000000000e-06 1.210446670365e-01
+ 1.978000000000e-06 1.211056462517e-01
+ 1.979000000000e-06 1.211666254669e-01
+ 1.980000000000e-06 1.212276046821e-01
+ 1.981000000000e-06 1.212885838973e-01
+ 1.982000000000e-06 1.213495631126e-01
+ 1.983000000000e-06 1.214105423278e-01
+ 1.984000000000e-06 1.214715215430e-01
+ 1.985000000000e-06 1.215325007582e-01
+ 1.986000000000e-06 1.215934799734e-01
+ 1.987000000000e-06 1.216544591886e-01
+ 1.988000000000e-06 1.217154384039e-01
+ 1.989000000000e-06 1.217764176191e-01
+ 1.990000000000e-06 1.218373968343e-01
+ 1.991000000000e-06 1.218983760495e-01
+ 1.992000000000e-06 1.219593552647e-01
+ 1.993000000000e-06 1.220203344799e-01
+ 1.994000000000e-06 1.220813136952e-01
+ 1.995000000000e-06 1.221422929104e-01
+ 1.996000000000e-06 1.222032721256e-01
+ 1.997000000000e-06 1.222642513408e-01
+ 1.998000000000e-06 1.223252305560e-01
+ 1.999000000000e-06 1.223862097712e-01
+ 2.000000000000e-06 1.224471889865e-01
+ 2.001000000000e-06 1.225081682017e-01
+ 2.002000000000e-06 1.225691474169e-01
+ 2.003000000000e-06 1.226301266321e-01
+ 2.004000000000e-06 1.226911058473e-01
+ 2.005000000000e-06 1.227520850625e-01
+ 2.006000000000e-06 1.228130642778e-01
+ 2.007000000000e-06 1.228740434930e-01
+ 2.008000000000e-06 1.229350227082e-01
+ 2.009000000000e-06 1.229960019234e-01
+ 2.010000000000e-06 1.230569811386e-01
+ 2.011000000000e-06 1.231179603538e-01
+ 2.012000000000e-06 1.231789395691e-01
+ 2.013000000000e-06 1.232399187843e-01
+ 2.014000000000e-06 1.233008979995e-01
+ 2.015000000000e-06 1.233618772147e-01
+ 2.016000000000e-06 1.234228564299e-01
+ 2.017000000000e-06 1.234838356451e-01
+ 2.018000000000e-06 1.235448148604e-01
+ 2.019000000000e-06 1.236057940756e-01
+ 2.020000000000e-06 1.236667732908e-01
+ 2.021000000000e-06 1.237277525060e-01
+ 2.022000000000e-06 1.237887317212e-01
+ 2.023000000000e-06 1.238497109364e-01
+ 2.024000000000e-06 1.239106901517e-01
+ 2.025000000000e-06 1.239716693669e-01
+ 2.026000000000e-06 1.240326485821e-01
+ 2.027000000000e-06 1.240936277973e-01
+ 2.028000000000e-06 1.241546070125e-01
+ 2.029000000000e-06 1.242155862277e-01
+ 2.030000000000e-06 1.242765654430e-01
+ 2.031000000000e-06 1.243375446582e-01
+ 2.032000000000e-06 1.243985238734e-01
+ 2.033000000000e-06 1.244595030886e-01
+ 2.034000000000e-06 1.245204823038e-01
+ 2.035000000000e-06 1.245814615190e-01
+ 2.036000000000e-06 1.246424407343e-01
+ 2.037000000000e-06 1.247034199495e-01
+ 2.038000000000e-06 1.247643991647e-01
+ 2.039000000000e-06 1.248253783799e-01
+ 2.040000000000e-06 1.248863575951e-01
+ 2.041000000000e-06 1.249473368103e-01
+ 2.042000000000e-06 1.250083160256e-01
+ 2.043000000000e-06 1.250692952408e-01
+ 2.044000000000e-06 1.251302744560e-01
+ 2.045000000000e-06 1.251912536712e-01
+ 2.046000000000e-06 1.252522328864e-01
+ 2.047000000000e-06 1.253132121016e-01
+ 2.048000000000e-06 1.253741913169e-01
+ 2.049000000000e-06 1.254351705321e-01
+ 2.050000000000e-06 1.254961497473e-01
+ 2.051000000000e-06 1.255571289625e-01
+ 2.052000000000e-06 1.256181081777e-01
+ 2.053000000000e-06 1.256790873929e-01
+ 2.054000000000e-06 1.257400666082e-01
+ 2.055000000000e-06 1.258010458234e-01
+ 2.056000000000e-06 1.258620250386e-01
+ 2.057000000000e-06 1.259230042538e-01
+ 2.058000000000e-06 1.259839834690e-01
+ 2.059000000000e-06 1.260449626842e-01
+ 2.060000000000e-06 1.261059418995e-01
+ 2.061000000000e-06 1.261669211147e-01
+ 2.062000000000e-06 1.262279003299e-01
+ 2.063000000000e-06 1.262888795451e-01
+ 2.064000000000e-06 1.263498587603e-01
+ 2.065000000000e-06 1.264108379755e-01
+ 2.066000000000e-06 1.264718171908e-01
+ 2.067000000000e-06 1.265327964060e-01
+ 2.068000000000e-06 1.265937756212e-01
+ 2.069000000000e-06 1.266547548364e-01
+ 2.070000000000e-06 1.267157340516e-01
+ 2.071000000000e-06 1.267767132668e-01
+ 2.072000000000e-06 1.268376924821e-01
+ 2.073000000000e-06 1.268986716973e-01
+ 2.074000000000e-06 1.269596509125e-01
+ 2.075000000000e-06 1.270206301277e-01
+ 2.076000000000e-06 1.270816093429e-01
+ 2.077000000000e-06 1.271425885581e-01
+ 2.078000000000e-06 1.272035677734e-01
+ 2.079000000000e-06 1.272645469886e-01
+ 2.080000000000e-06 1.273255262038e-01
+ 2.081000000000e-06 1.273865054190e-01
+ 2.082000000000e-06 1.274474846342e-01
+ 2.083000000000e-06 1.275084638494e-01
+ 2.084000000000e-06 1.275694430647e-01
+ 2.085000000000e-06 1.276304222799e-01
+ 2.086000000000e-06 1.276914014951e-01
+ 2.087000000000e-06 1.277523807103e-01
+ 2.088000000000e-06 1.278133599255e-01
+ 2.089000000000e-06 1.278743391407e-01
+ 2.090000000000e-06 1.279353183560e-01
+ 2.091000000000e-06 1.279962975712e-01
+ 2.092000000000e-06 1.280572767864e-01
+ 2.093000000000e-06 1.281182560016e-01
+ 2.094000000000e-06 1.281792352168e-01
+ 2.095000000000e-06 1.282402144320e-01
+ 2.096000000000e-06 1.283011936473e-01
+ 2.097000000000e-06 1.283621728625e-01
+ 2.098000000000e-06 1.284231520777e-01
+ 2.099000000000e-06 1.284841312929e-01
+ 2.100000000000e-06 1.285451105081e-01
+ 2.101000000000e-06 1.286060897233e-01
+ 2.102000000000e-06 1.286670689386e-01
+ 2.103000000000e-06 1.287280481538e-01
+ 2.104000000000e-06 1.287890273690e-01
+ 2.105000000000e-06 1.288500065842e-01
+ 2.106000000000e-06 1.289109857994e-01
+ 2.107000000000e-06 1.289719650146e-01
+ 2.108000000000e-06 1.290329442299e-01
+ 2.109000000000e-06 1.290939234451e-01
+ 2.110000000000e-06 1.291549026603e-01
+ 2.111000000000e-06 1.292158818755e-01
+ 2.112000000000e-06 1.292768610907e-01
+ 2.113000000000e-06 1.293378403059e-01
+ 2.114000000000e-06 1.293988195212e-01
+ 2.115000000000e-06 1.294597987364e-01
+ 2.116000000000e-06 1.295207779516e-01
+ 2.117000000000e-06 1.295817571668e-01
+ 2.118000000000e-06 1.296427363820e-01
+ 2.119000000000e-06 1.297037155972e-01
+ 2.120000000000e-06 1.297646948125e-01
+ 2.121000000000e-06 1.298256740277e-01
+ 2.122000000000e-06 1.298866532429e-01
+ 2.123000000000e-06 1.299476324581e-01
+ 2.124000000000e-06 1.300086116733e-01
+ 2.125000000000e-06 1.300695908885e-01
+ 2.126000000000e-06 1.301305701038e-01
+ 2.127000000000e-06 1.301915493190e-01
+ 2.128000000000e-06 1.302525285342e-01
+ 2.129000000000e-06 1.303135077494e-01
+ 2.130000000000e-06 1.303744869646e-01
+ 2.131000000000e-06 1.304354661798e-01
+ 2.132000000000e-06 1.304964453951e-01
+ 2.133000000000e-06 1.305574246103e-01
+ 2.134000000000e-06 1.306184038255e-01
+ 2.135000000000e-06 1.306793830407e-01
+ 2.136000000000e-06 1.307403622559e-01
+ 2.137000000000e-06 1.308013414711e-01
+ 2.138000000000e-06 1.308623206864e-01
+ 2.139000000000e-06 1.309232999016e-01
+ 2.140000000000e-06 1.309842791168e-01
+ 2.141000000000e-06 1.310452583320e-01
+ 2.142000000000e-06 1.311062375472e-01
+ 2.143000000000e-06 1.311672167624e-01
+ 2.144000000000e-06 1.312281959777e-01
+ 2.145000000000e-06 1.312891751929e-01
+ 2.146000000000e-06 1.313501544081e-01
+ 2.147000000000e-06 1.314111336233e-01
+ 2.148000000000e-06 1.314721128385e-01
+ 2.149000000000e-06 1.315330920537e-01
+ 2.150000000000e-06 1.315940712690e-01
+ 2.151000000000e-06 1.316550504842e-01
+ 2.152000000000e-06 1.317160296994e-01
+ 2.153000000000e-06 1.317770089146e-01
+ 2.154000000000e-06 1.318379881298e-01
+ 2.155000000000e-06 1.318989673450e-01
+ 2.156000000000e-06 1.319599465603e-01
+ 2.157000000000e-06 1.320209257755e-01
+ 2.158000000000e-06 1.320819049907e-01
+ 2.159000000000e-06 1.321428842059e-01
+ 2.160000000000e-06 1.322038634211e-01
+ 2.161000000000e-06 1.322648426363e-01
+ 2.162000000000e-06 1.323258218515e-01
+ 2.163000000000e-06 1.323868010668e-01
+ 2.164000000000e-06 1.324477802820e-01
+ 2.165000000000e-06 1.325087594972e-01
+ 2.166000000000e-06 1.325697387124e-01
+ 2.167000000000e-06 1.326307179276e-01
+ 2.168000000000e-06 1.326916971428e-01
+ 2.169000000000e-06 1.327526763581e-01
+ 2.170000000000e-06 1.328136555733e-01
+ 2.171000000000e-06 1.328746347885e-01
+ 2.172000000000e-06 1.329356140037e-01
+ 2.173000000000e-06 1.329965932189e-01
+ 2.174000000000e-06 1.330575724341e-01
+ 2.175000000000e-06 1.331185516494e-01
+ 2.176000000000e-06 1.331795308646e-01
+ 2.177000000000e-06 1.332405100798e-01
+ 2.178000000000e-06 1.333014892950e-01
+ 2.179000000000e-06 1.333624685102e-01
+ 2.180000000000e-06 1.334234477254e-01
+ 2.181000000000e-06 1.334844269407e-01
+ 2.182000000000e-06 1.335454061559e-01
+ 2.183000000000e-06 1.336063853711e-01
+ 2.184000000000e-06 1.336673645863e-01
+ 2.185000000000e-06 1.337283438015e-01
+ 2.186000000000e-06 1.337893230167e-01
+ 2.187000000000e-06 1.338503022320e-01
+ 2.188000000000e-06 1.339112814472e-01
+ 2.189000000000e-06 1.339722606624e-01
+ 2.190000000000e-06 1.340332398776e-01
+ 2.191000000000e-06 1.340942190928e-01
+ 2.192000000000e-06 1.341551983080e-01
+ 2.193000000000e-06 1.342161775233e-01
+ 2.194000000000e-06 1.342771567385e-01
+ 2.195000000000e-06 1.343381359537e-01
+ 2.196000000000e-06 1.343991151689e-01
+ 2.197000000000e-06 1.344600943841e-01
+ 2.198000000000e-06 1.345210735993e-01
+ 2.199000000000e-06 1.345820528146e-01
+ 2.200000000000e-06 1.346430320298e-01
+ 2.201000000000e-06 1.347040112450e-01
+ 2.202000000000e-06 1.347649904602e-01
+ 2.203000000000e-06 1.348259696754e-01
+ 2.204000000000e-06 1.348869488906e-01
+ 2.205000000000e-06 1.349479281059e-01
+ 2.206000000000e-06 1.350089073211e-01
+ 2.207000000000e-06 1.350698865363e-01
+ 2.208000000000e-06 1.351308657515e-01
+ 2.209000000000e-06 1.351918449667e-01
+ 2.210000000000e-06 1.352528241819e-01
+ 2.211000000000e-06 1.353138033972e-01
+ 2.212000000000e-06 1.353747826124e-01
+ 2.213000000000e-06 1.354357618276e-01
+ 2.214000000000e-06 1.354967410428e-01
+ 2.215000000000e-06 1.355577202580e-01
+ 2.216000000000e-06 1.356186994732e-01
+ 2.217000000000e-06 1.356796786885e-01
+ 2.218000000000e-06 1.357406579037e-01
+ 2.219000000000e-06 1.358016371189e-01
+ 2.220000000000e-06 1.358626163341e-01
+ 2.221000000000e-06 1.359235955493e-01
+ 2.222000000000e-06 1.359845747645e-01
+ 2.223000000000e-06 1.360455539798e-01
+ 2.224000000000e-06 1.361065331950e-01
+ 2.225000000000e-06 1.361675124102e-01
+ 2.226000000000e-06 1.362284916254e-01
+ 2.227000000000e-06 1.362894708406e-01
+ 2.228000000000e-06 1.363504500558e-01
+ 2.229000000000e-06 1.364114292711e-01
+ 2.230000000000e-06 1.364724084863e-01
+ 2.231000000000e-06 1.365333877015e-01
+ 2.232000000000e-06 1.365943669167e-01
+ 2.233000000000e-06 1.366553461319e-01
+ 2.234000000000e-06 1.367163253471e-01
+ 2.235000000000e-06 1.367773045624e-01
+ 2.236000000000e-06 1.368382837776e-01
+ 2.237000000000e-06 1.368992629928e-01
+ 2.238000000000e-06 1.369602422080e-01
+ 2.239000000000e-06 1.370212214232e-01
+ 2.240000000000e-06 1.370822006384e-01
+ 2.241000000000e-06 1.371431798537e-01
+ 2.242000000000e-06 1.372041590689e-01
+ 2.243000000000e-06 1.372651382841e-01
+ 2.244000000000e-06 1.373261174993e-01
+ 2.245000000000e-06 1.373870967145e-01
+ 2.246000000000e-06 1.374480759297e-01
+ 2.247000000000e-06 1.375090551450e-01
+ 2.248000000000e-06 1.375700343602e-01
+ 2.249000000000e-06 1.376310135754e-01
+ 2.250000000000e-06 1.376919927906e-01
+ 2.251000000000e-06 1.377529720058e-01
+ 2.252000000000e-06 1.378139512210e-01
+ 2.253000000000e-06 1.378749304363e-01
+ 2.254000000000e-06 1.379359096515e-01
+ 2.255000000000e-06 1.379968888667e-01
+ 2.256000000000e-06 1.380578680819e-01
+ 2.257000000000e-06 1.381188472971e-01
+ 2.258000000000e-06 1.381798265123e-01
+ 2.259000000000e-06 1.382408057276e-01
+ 2.260000000000e-06 1.383017849428e-01
+ 2.261000000000e-06 1.383627641580e-01
+ 2.262000000000e-06 1.384237433732e-01
+ 2.263000000000e-06 1.384847225884e-01
+ 2.264000000000e-06 1.385457018036e-01
+ 2.265000000000e-06 1.386066810189e-01
+ 2.266000000000e-06 1.386676602341e-01
+ 2.267000000000e-06 1.387286394493e-01
+ 2.268000000000e-06 1.387896186645e-01
+ 2.269000000000e-06 1.388505978797e-01
+ 2.270000000000e-06 1.389115770949e-01
+ 2.271000000000e-06 1.389725563102e-01
+ 2.272000000000e-06 1.390335355254e-01
+ 2.273000000000e-06 1.390945147406e-01
+ 2.274000000000e-06 1.391554939558e-01
+ 2.275000000000e-06 1.392164731710e-01
+ 2.276000000000e-06 1.392774523862e-01
+ 2.277000000000e-06 1.393384316015e-01
+ 2.278000000000e-06 1.393994108167e-01
+ 2.279000000000e-06 1.394603900319e-01
+ 2.280000000000e-06 1.395213692471e-01
+ 2.281000000000e-06 1.395823484623e-01
+ 2.282000000000e-06 1.396433276775e-01
+ 2.283000000000e-06 1.397043068928e-01
+ 2.284000000000e-06 1.397652861080e-01
+ 2.285000000000e-06 1.398262653232e-01
+ 2.286000000000e-06 1.398872445384e-01
+ 2.287000000000e-06 1.399482237536e-01
+ 2.288000000000e-06 1.400092029688e-01
+ 2.289000000000e-06 1.400701821841e-01
+ 2.290000000000e-06 1.401311613993e-01
+ 2.291000000000e-06 1.401921406145e-01
+ 2.292000000000e-06 1.402531198297e-01
+ 2.293000000000e-06 1.403140990449e-01
+ 2.294000000000e-06 1.403750782601e-01
+ 2.295000000000e-06 1.404360574754e-01
+ 2.296000000000e-06 1.404970366906e-01
+ 2.297000000000e-06 1.405580159058e-01
+ 2.298000000000e-06 1.406189951210e-01
+ 2.299000000000e-06 1.406799743362e-01
+ 2.300000000000e-06 1.407409535514e-01
+ 2.301000000000e-06 1.408019327667e-01
+ 2.302000000000e-06 1.408629119819e-01
+ 2.303000000000e-06 1.409238911971e-01
+ 2.304000000000e-06 1.409848704123e-01
+ 2.305000000000e-06 1.410458496275e-01
+ 2.306000000000e-06 1.411068288427e-01
+ 2.307000000000e-06 1.411678080580e-01
+ 2.308000000000e-06 1.412287872732e-01
+ 2.309000000000e-06 1.412897664884e-01
+ 2.310000000000e-06 1.413507457036e-01
+ 2.311000000000e-06 1.414117249188e-01
+ 2.312000000000e-06 1.414727041340e-01
+ 2.313000000000e-06 1.415336833493e-01
+ 2.314000000000e-06 1.415946625645e-01
+ 2.315000000000e-06 1.416556417797e-01
+ 2.316000000000e-06 1.417166209949e-01
+ 2.317000000000e-06 1.417776002101e-01
+ 2.318000000000e-06 1.418385794253e-01
+ 2.319000000000e-06 1.418995586406e-01
+ 2.320000000000e-06 1.419605378558e-01
+ 2.321000000000e-06 1.420215170710e-01
+ 2.322000000000e-06 1.420824962862e-01
+ 2.323000000000e-06 1.421434755014e-01
+ 2.324000000000e-06 1.422044547166e-01
+ 2.325000000000e-06 1.422654339319e-01
+ 2.326000000000e-06 1.423264131471e-01
+ 2.327000000000e-06 1.423873923623e-01
+ 2.328000000000e-06 1.424483715775e-01
+ 2.329000000000e-06 1.425093507927e-01
+ 2.330000000000e-06 1.425703300079e-01
+ 2.331000000000e-06 1.426313092232e-01
+ 2.332000000000e-06 1.426922884384e-01
+ 2.333000000000e-06 1.427532676536e-01
+ 2.334000000000e-06 1.428142468688e-01
+ 2.335000000000e-06 1.428752260840e-01
+ 2.336000000000e-06 1.429362052992e-01
+ 2.337000000000e-06 1.429971845145e-01
+ 2.338000000000e-06 1.430581637297e-01
+ 2.339000000000e-06 1.431191429449e-01
+ 2.340000000000e-06 1.431801221601e-01
+ 2.341000000000e-06 1.432411013753e-01
+ 2.342000000000e-06 1.433020805905e-01
+ 2.343000000000e-06 1.433630598058e-01
+ 2.344000000000e-06 1.434240390210e-01
+ 2.345000000000e-06 1.434850182362e-01
+ 2.346000000000e-06 1.435459974514e-01
+ 2.347000000000e-06 1.436069766666e-01
+ 2.348000000000e-06 1.436679558818e-01
+ 2.349000000000e-06 1.437289350971e-01
+ 2.350000000000e-06 1.437899143123e-01
+ 2.351000000000e-06 1.438508935275e-01
+ 2.352000000000e-06 1.439118727427e-01
+ 2.353000000000e-06 1.439728519579e-01
+ 2.354000000000e-06 1.440338311731e-01
+ 2.355000000000e-06 1.440948103884e-01
+ 2.356000000000e-06 1.441557896036e-01
+ 2.357000000000e-06 1.442167688188e-01
+ 2.358000000000e-06 1.442777480340e-01
+ 2.359000000000e-06 1.443387272492e-01
+ 2.360000000000e-06 1.443997064644e-01
+ 2.361000000000e-06 1.444606856797e-01
+ 2.362000000000e-06 1.445216648949e-01
+ 2.363000000000e-06 1.445826441101e-01
+ 2.364000000000e-06 1.446436233253e-01
+ 2.365000000000e-06 1.447046025405e-01
+ 2.366000000000e-06 1.447655817557e-01
+ 2.367000000000e-06 1.448265609710e-01
+ 2.368000000000e-06 1.448875401862e-01
+ 2.369000000000e-06 1.449485194014e-01
+ 2.370000000000e-06 1.450094986166e-01
+ 2.371000000000e-06 1.450704778318e-01
+ 2.372000000000e-06 1.451314570470e-01
+ 2.373000000000e-06 1.451924362623e-01
+ 2.374000000000e-06 1.452534154775e-01
+ 2.375000000000e-06 1.453143946927e-01
+ 2.376000000000e-06 1.453753739079e-01
+ 2.377000000000e-06 1.454363531231e-01
+ 2.378000000000e-06 1.454973323383e-01
+ 2.379000000000e-06 1.455583115536e-01
+ 2.380000000000e-06 1.456192907688e-01
+ 2.381000000000e-06 1.456802699840e-01
+ 2.382000000000e-06 1.457412491992e-01
+ 2.383000000000e-06 1.458022284144e-01
+ 2.384000000000e-06 1.458632076296e-01
+ 2.385000000000e-06 1.459241868449e-01
+ 2.386000000000e-06 1.459851660601e-01
+ 2.387000000000e-06 1.460461452753e-01
+ 2.388000000000e-06 1.461071244905e-01
+ 2.389000000000e-06 1.461681037057e-01
+ 2.390000000000e-06 1.462290829209e-01
+ 2.391000000000e-06 1.462900621361e-01
+ 2.392000000000e-06 1.463510413514e-01
+ 2.393000000000e-06 1.464120205666e-01
+ 2.394000000000e-06 1.464729997818e-01
+ 2.395000000000e-06 1.465339789970e-01
+ 2.396000000000e-06 1.465949582122e-01
+ 2.397000000000e-06 1.466559374274e-01
+ 2.398000000000e-06 1.467169166427e-01
+ 2.399000000000e-06 1.467778958579e-01
+ 2.400000000000e-06 1.468388750731e-01
+ 2.401000000000e-06 1.468998542883e-01
+ 2.402000000000e-06 1.469608335035e-01
+ 2.403000000000e-06 1.470218127187e-01
+ 2.404000000000e-06 1.470827919340e-01
+ 2.405000000000e-06 1.471437711492e-01
+ 2.406000000000e-06 1.472047503644e-01
+ 2.407000000000e-06 1.472657295796e-01
+ 2.408000000000e-06 1.473267087948e-01
+ 2.409000000000e-06 1.473876880100e-01
+ 2.410000000000e-06 1.474486672253e-01
+ 2.411000000000e-06 1.475096464405e-01
+ 2.412000000000e-06 1.475706256557e-01
+ 2.413000000000e-06 1.476316048709e-01
+ 2.414000000000e-06 1.476925840861e-01
+ 2.415000000000e-06 1.477535633013e-01
+ 2.416000000000e-06 1.478145425166e-01
+ 2.417000000000e-06 1.478755217318e-01
+ 2.418000000000e-06 1.479365009470e-01
+ 2.419000000000e-06 1.479974801622e-01
+ 2.420000000000e-06 1.480584593774e-01
+ 2.421000000000e-06 1.481194385926e-01
+ 2.422000000000e-06 1.481804178079e-01
+ 2.423000000000e-06 1.482413970231e-01
+ 2.424000000000e-06 1.483023762383e-01
+ 2.425000000000e-06 1.483633554535e-01
+ 2.426000000000e-06 1.484243346687e-01
+ 2.427000000000e-06 1.484853138839e-01
+ 2.428000000000e-06 1.485462930992e-01
+ 2.429000000000e-06 1.486072723144e-01
+ 2.430000000000e-06 1.486682515296e-01
+ 2.431000000000e-06 1.487292307448e-01
+ 2.432000000000e-06 1.487902099600e-01
+ 2.433000000000e-06 1.488511891752e-01
+ 2.434000000000e-06 1.489121683905e-01
+ 2.435000000000e-06 1.489731476057e-01
+ 2.436000000000e-06 1.490341268209e-01
+ 2.437000000000e-06 1.490951060361e-01
+ 2.438000000000e-06 1.491560852513e-01
+ 2.439000000000e-06 1.492170644665e-01
+ 2.440000000000e-06 1.492780436818e-01
+ 2.441000000000e-06 1.493390228970e-01
+ 2.442000000000e-06 1.494000021122e-01
+ 2.443000000000e-06 1.494609813274e-01
+ 2.444000000000e-06 1.495219605426e-01
+ 2.445000000000e-06 1.495829397578e-01
+ 2.446000000000e-06 1.496439189731e-01
+ 2.447000000000e-06 1.497048981883e-01
+ 2.448000000000e-06 1.497658774035e-01
+ 2.449000000000e-06 1.498268566187e-01
+ 2.450000000000e-06 1.498878358339e-01
+ 2.451000000000e-06 1.499488150491e-01
+ 2.452000000000e-06 1.500097942644e-01
+ 2.453000000000e-06 1.500707734796e-01
+ 2.454000000000e-06 1.501317526948e-01
+ 2.455000000000e-06 1.501927319100e-01
+ 2.456000000000e-06 1.502537111252e-01
+ 2.457000000000e-06 1.503146903404e-01
+ 2.458000000000e-06 1.503756695557e-01
+ 2.459000000000e-06 1.504366487709e-01
+ 2.460000000000e-06 1.504976279861e-01
+ 2.461000000000e-06 1.505586072013e-01
+ 2.462000000000e-06 1.506195864165e-01
+ 2.463000000000e-06 1.506805656317e-01
+ 2.464000000000e-06 1.507415448470e-01
+ 2.465000000000e-06 1.508025240622e-01
+ 2.466000000000e-06 1.508635032774e-01
+ 2.467000000000e-06 1.509244824926e-01
+ 2.468000000000e-06 1.509854617078e-01
+ 2.469000000000e-06 1.510464409230e-01
+ 2.470000000000e-06 1.511074201383e-01
+ 2.471000000000e-06 1.511683993535e-01
+ 2.472000000000e-06 1.512293785687e-01
+ 2.473000000000e-06 1.512903577839e-01
+ 2.474000000000e-06 1.513513369991e-01
+ 2.475000000000e-06 1.514123162143e-01
+ 2.476000000000e-06 1.514732954296e-01
+ 2.477000000000e-06 1.515342746448e-01
+ 2.478000000000e-06 1.515952538600e-01
+ 2.479000000000e-06 1.516562330752e-01
+ 2.480000000000e-06 1.517172122904e-01
+ 2.481000000000e-06 1.517781915056e-01
+ 2.482000000000e-06 1.518391707209e-01
+ 2.483000000000e-06 1.519001499361e-01
+ 2.484000000000e-06 1.519611291513e-01
+ 2.485000000000e-06 1.520221083665e-01
+ 2.486000000000e-06 1.520830875817e-01
+ 2.487000000000e-06 1.521440667969e-01
+ 2.488000000000e-06 1.522050460122e-01
+ 2.489000000000e-06 1.522660252274e-01
+ 2.490000000000e-06 1.523270044426e-01
+ 2.491000000000e-06 1.523879836578e-01
+ 2.492000000000e-06 1.524489628730e-01
+ 2.493000000000e-06 1.525099420882e-01
+ 2.494000000000e-06 1.525709213035e-01
+ 2.495000000000e-06 1.526319005187e-01
+ 2.496000000000e-06 1.526928797339e-01
+ 2.497000000000e-06 1.527538589491e-01
+ 2.498000000000e-06 1.528148381643e-01
+ 2.499000000000e-06 1.528758173795e-01
+ 2.500000000000e-06 1.529367965948e-01
+ 2.501000000000e-06 1.529977758100e-01
+ 2.502000000000e-06 1.530587550252e-01
+ 2.503000000000e-06 1.531197342404e-01
+ 2.504000000000e-06 1.531807134556e-01
+ 2.505000000000e-06 1.532416926708e-01
+ 2.506000000000e-06 1.533026718861e-01
+ 2.507000000000e-06 1.533636511013e-01
+ 2.508000000000e-06 1.534246303165e-01
+ 2.509000000000e-06 1.534856095317e-01
+ 2.510000000000e-06 1.535465887469e-01
+ 2.511000000000e-06 1.536075679621e-01
+ 2.512000000000e-06 1.536685471774e-01
+ 2.513000000000e-06 1.537295263926e-01
+ 2.514000000000e-06 1.537905056078e-01
+ 2.515000000000e-06 1.538514848230e-01
+ 2.516000000000e-06 1.539124640382e-01
+ 2.517000000000e-06 1.539734432534e-01
+ 2.518000000000e-06 1.540344224687e-01
+ 2.519000000000e-06 1.540954016839e-01
+ 2.520000000000e-06 1.541563808991e-01
+ 2.521000000000e-06 1.542173601143e-01
+ 2.522000000000e-06 1.542783393295e-01
+ 2.523000000000e-06 1.543393185447e-01
+ 2.524000000000e-06 1.544002977600e-01
+ 2.525000000000e-06 1.544612769752e-01
+ 2.526000000000e-06 1.545222561904e-01
+ 2.527000000000e-06 1.545832354056e-01
+ 2.528000000000e-06 1.546442146208e-01
+ 2.529000000000e-06 1.547051938360e-01
+ 2.530000000000e-06 1.547661730513e-01
+ 2.531000000000e-06 1.548271522665e-01
+ 2.532000000000e-06 1.548881314817e-01
+ 2.533000000000e-06 1.549491106969e-01
+ 2.534000000000e-06 1.550100899121e-01
+ 2.535000000000e-06 1.550710691273e-01
+ 2.536000000000e-06 1.551320483426e-01
+ 2.537000000000e-06 1.551930275578e-01
+ 2.538000000000e-06 1.552540067730e-01
+ 2.539000000000e-06 1.553149859882e-01
+ 2.540000000000e-06 1.553759652034e-01
+ 2.541000000000e-06 1.554369444186e-01
+ 2.542000000000e-06 1.554979236339e-01
+ 2.543000000000e-06 1.555589028491e-01
+ 2.544000000000e-06 1.556198820643e-01
+ 2.545000000000e-06 1.556808612795e-01
+ 2.546000000000e-06 1.557418404947e-01
+ 2.547000000000e-06 1.558028197099e-01
+ 2.548000000000e-06 1.558637989252e-01
+ 2.549000000000e-06 1.559247781404e-01
+ 2.550000000000e-06 1.559857573556e-01
+ 2.551000000000e-06 1.560467365708e-01
+ 2.552000000000e-06 1.561077157860e-01
+ 2.553000000000e-06 1.561686950012e-01
+ 2.554000000000e-06 1.562296742165e-01
+ 2.555000000000e-06 1.562906534317e-01
+ 2.556000000000e-06 1.563516326469e-01
+ 2.557000000000e-06 1.564126118621e-01
+ 2.558000000000e-06 1.564735910773e-01
+ 2.559000000000e-06 1.565345702925e-01
+ 2.560000000000e-06 1.565955495078e-01
+ 2.561000000000e-06 1.566565287230e-01
+ 2.562000000000e-06 1.567175079382e-01
+ 2.563000000000e-06 1.567784871534e-01
+ 2.564000000000e-06 1.568394663686e-01
+ 2.565000000000e-06 1.569004455838e-01
+ 2.566000000000e-06 1.569614247991e-01
+ 2.567000000000e-06 1.570224040143e-01
+ 2.568000000000e-06 1.570833832295e-01
+ 2.569000000000e-06 1.571443624447e-01
+ 2.570000000000e-06 1.572053416599e-01
+ 2.571000000000e-06 1.572663208751e-01
+ 2.572000000000e-06 1.573273000904e-01
+ 2.573000000000e-06 1.573882793056e-01
+ 2.574000000000e-06 1.574492585208e-01
+ 2.575000000000e-06 1.575102377360e-01
+ 2.576000000000e-06 1.575712169512e-01
+ 2.577000000000e-06 1.576321961664e-01
+ 2.578000000000e-06 1.576931753817e-01
+ 2.579000000000e-06 1.577541545969e-01
+ 2.580000000000e-06 1.578151338121e-01
+ 2.581000000000e-06 1.578761130273e-01
+ 2.582000000000e-06 1.579370922425e-01
+ 2.583000000000e-06 1.579980714577e-01
+ 2.584000000000e-06 1.580590506730e-01
+ 2.585000000000e-06 1.581200298882e-01
+ 2.586000000000e-06 1.581810091034e-01
+ 2.587000000000e-06 1.582419883186e-01
+ 2.588000000000e-06 1.583029675338e-01
+ 2.589000000000e-06 1.583639467490e-01
+ 2.590000000000e-06 1.584249259643e-01
+ 2.591000000000e-06 1.584859051795e-01
+ 2.592000000000e-06 1.585468843947e-01
+ 2.593000000000e-06 1.586078636099e-01
+ 2.594000000000e-06 1.586688428251e-01
+ 2.595000000000e-06 1.587298220403e-01
+ 2.596000000000e-06 1.587908012556e-01
+ 2.597000000000e-06 1.588517804708e-01
+ 2.598000000000e-06 1.589127596860e-01
+ 2.599000000000e-06 1.589737389012e-01
+ 2.600000000000e-06 1.590347181164e-01
+ 2.601000000000e-06 1.590956973316e-01
+ 2.602000000000e-06 1.591566765469e-01
+ 2.603000000000e-06 1.592176557621e-01
+ 2.604000000000e-06 1.592786349773e-01
+ 2.605000000000e-06 1.593396141925e-01
+ 2.606000000000e-06 1.594005934077e-01
+ 2.607000000000e-06 1.594615726229e-01
+ 2.608000000000e-06 1.595225518382e-01
+ 2.609000000000e-06 1.595835310534e-01
+ 2.610000000000e-06 1.596445102686e-01
+ 2.611000000000e-06 1.597054894838e-01
+ 2.612000000000e-06 1.597664686990e-01
+ 2.613000000000e-06 1.598274479142e-01
+ 2.614000000000e-06 1.598884271294e-01
+ 2.615000000000e-06 1.599494063447e-01
+ 2.616000000000e-06 1.600103855599e-01
+ 2.617000000000e-06 1.600713647751e-01
+ 2.618000000000e-06 1.601323439903e-01
+ 2.619000000000e-06 1.601933232055e-01
+ 2.620000000000e-06 1.602543024207e-01
+ 2.621000000000e-06 1.603152816360e-01
+ 2.622000000000e-06 1.603762608512e-01
+ 2.623000000000e-06 1.604372400664e-01
+ 2.624000000000e-06 1.604982192816e-01
+ 2.625000000000e-06 1.605591984968e-01
+ 2.626000000000e-06 1.606201777120e-01
+ 2.627000000000e-06 1.606811569273e-01
+ 2.628000000000e-06 1.607421361425e-01
+ 2.629000000000e-06 1.608031153577e-01
+ 2.630000000000e-06 1.608640945729e-01
+ 2.631000000000e-06 1.609250737881e-01
+ 2.632000000000e-06 1.609860530033e-01
+ 2.633000000000e-06 1.610470322186e-01
+ 2.634000000000e-06 1.611080114338e-01
+ 2.635000000000e-06 1.611689906490e-01
+ 2.636000000000e-06 1.612299698642e-01
+ 2.637000000000e-06 1.612909490794e-01
+ 2.638000000000e-06 1.613519282946e-01
+ 2.639000000000e-06 1.614129075099e-01
+ 2.640000000000e-06 1.614738867251e-01
+ 2.641000000000e-06 1.615348659403e-01
+ 2.642000000000e-06 1.615958451555e-01
+ 2.643000000000e-06 1.616568243707e-01
+ 2.644000000000e-06 1.617178035859e-01
+ 2.645000000000e-06 1.617787828012e-01
+ 2.646000000000e-06 1.618397620164e-01
+ 2.647000000000e-06 1.619007412316e-01
+ 2.648000000000e-06 1.619617204468e-01
+ 2.649000000000e-06 1.620226996620e-01
+ 2.650000000000e-06 1.620836788772e-01
+ 2.651000000000e-06 1.621446580925e-01
+ 2.652000000000e-06 1.622056373077e-01
+ 2.653000000000e-06 1.622666165229e-01
+ 2.654000000000e-06 1.623275957381e-01
+ 2.655000000000e-06 1.623885749533e-01
+ 2.656000000000e-06 1.624495541685e-01
+ 2.657000000000e-06 1.625105333838e-01
+ 2.658000000000e-06 1.625715125990e-01
+ 2.659000000000e-06 1.626324918142e-01
+ 2.660000000000e-06 1.626934710294e-01
+ 2.661000000000e-06 1.627544502446e-01
+ 2.662000000000e-06 1.628154294598e-01
+ 2.663000000000e-06 1.628764086751e-01
+ 2.664000000000e-06 1.629373878903e-01
+ 2.665000000000e-06 1.629983671055e-01
+ 2.666000000000e-06 1.630593463207e-01
+ 2.667000000000e-06 1.631203255359e-01
+ 2.668000000000e-06 1.631813047511e-01
+ 2.669000000000e-06 1.632422839664e-01
+ 2.670000000000e-06 1.633032631816e-01
+ 2.671000000000e-06 1.633642423968e-01
+ 2.672000000000e-06 1.634252216120e-01
+ 2.673000000000e-06 1.634862008272e-01
+ 2.674000000000e-06 1.635471800424e-01
+ 2.675000000000e-06 1.636081592577e-01
+ 2.676000000000e-06 1.636691384729e-01
+ 2.677000000000e-06 1.637301176881e-01
+ 2.678000000000e-06 1.637910969033e-01
+ 2.679000000000e-06 1.638520761185e-01
+ 2.680000000000e-06 1.639130553337e-01
+ 2.681000000000e-06 1.639740345490e-01
+ 2.682000000000e-06 1.640350137642e-01
+ 2.683000000000e-06 1.640959929794e-01
+ 2.684000000000e-06 1.641569721946e-01
+ 2.685000000000e-06 1.642179514098e-01
+ 2.686000000000e-06 1.642789306250e-01
+ 2.687000000000e-06 1.643399098403e-01
+ 2.688000000000e-06 1.644008890555e-01
+ 2.689000000000e-06 1.644618682707e-01
+ 2.690000000000e-06 1.645228474859e-01
+ 2.691000000000e-06 1.645838267011e-01
+ 2.692000000000e-06 1.646448059163e-01
+ 2.693000000000e-06 1.647057851316e-01
+ 2.694000000000e-06 1.647667643468e-01
+ 2.695000000000e-06 1.648277435620e-01
+ 2.696000000000e-06 1.648887227772e-01
+ 2.697000000000e-06 1.649497019924e-01
+ 2.698000000000e-06 1.650106812076e-01
+ 2.699000000000e-06 1.650716604229e-01
+ 2.700000000000e-06 1.651326396381e-01
+ 2.701000000000e-06 1.651936188533e-01
+ 2.702000000000e-06 1.652545980685e-01
+ 2.703000000000e-06 1.653155772837e-01
+ 2.704000000000e-06 1.653765564989e-01
+ 2.705000000000e-06 1.654375357142e-01
+ 2.706000000000e-06 1.654985149294e-01
+ 2.707000000000e-06 1.655594941446e-01
+ 2.708000000000e-06 1.656204733598e-01
+ 2.709000000000e-06 1.656814525750e-01
+ 2.710000000000e-06 1.657424317902e-01
+ 2.711000000000e-06 1.658034110055e-01
+ 2.712000000000e-06 1.658643902207e-01
+ 2.713000000000e-06 1.659253694359e-01
+ 2.714000000000e-06 1.659863486511e-01
+ 2.715000000000e-06 1.660473278663e-01
+ 2.716000000000e-06 1.661083070815e-01
+ 2.717000000000e-06 1.661692862968e-01
+ 2.718000000000e-06 1.662302655120e-01
+ 2.719000000000e-06 1.662912447272e-01
+ 2.720000000000e-06 1.663522239424e-01
+ 2.721000000000e-06 1.664132031576e-01
+ 2.722000000000e-06 1.664741823728e-01
+ 2.723000000000e-06 1.665351615881e-01
+ 2.724000000000e-06 1.665961408033e-01
+ 2.725000000000e-06 1.666571200185e-01
+ 2.726000000000e-06 1.667180992337e-01
+ 2.727000000000e-06 1.667790784489e-01
+ 2.728000000000e-06 1.668400576641e-01
+ 2.729000000000e-06 1.669010368794e-01
+ 2.730000000000e-06 1.669620160946e-01
+ 2.731000000000e-06 1.670229953098e-01
+ 2.732000000000e-06 1.670839745250e-01
+ 2.733000000000e-06 1.671449537402e-01
+ 2.734000000000e-06 1.672059329554e-01
+ 2.735000000000e-06 1.672669121707e-01
+ 2.736000000000e-06 1.673278913859e-01
+ 2.737000000000e-06 1.673888706011e-01
+ 2.738000000000e-06 1.674498498163e-01
+ 2.739000000000e-06 1.675108290315e-01
+ 2.740000000000e-06 1.675718082467e-01
+ 2.741000000000e-06 1.676327874620e-01
+ 2.742000000000e-06 1.676937666772e-01
+ 2.743000000000e-06 1.677547458924e-01
+ 2.744000000000e-06 1.678157251076e-01
+ 2.745000000000e-06 1.678767043228e-01
+ 2.746000000000e-06 1.679376835380e-01
+ 2.747000000000e-06 1.679986627533e-01
+ 2.748000000000e-06 1.680596419685e-01
+ 2.749000000000e-06 1.681206211837e-01
+ 2.750000000000e-06 1.681816003989e-01
+ 2.751000000000e-06 1.682425796141e-01
+ 2.752000000000e-06 1.683035588293e-01
+ 2.753000000000e-06 1.683645380446e-01
+ 2.754000000000e-06 1.684255172598e-01
+ 2.755000000000e-06 1.684864964750e-01
+ 2.756000000000e-06 1.685474756902e-01
+ 2.757000000000e-06 1.686084549054e-01
+ 2.758000000000e-06 1.686694341206e-01
+ 2.759000000000e-06 1.687304133359e-01
+ 2.760000000000e-06 1.687913925511e-01
+ 2.761000000000e-06 1.688523717663e-01
+ 2.762000000000e-06 1.689133509815e-01
+ 2.763000000000e-06 1.689743301967e-01
+ 2.764000000000e-06 1.690353094119e-01
+ 2.765000000000e-06 1.690962886272e-01
+ 2.766000000000e-06 1.691572678424e-01
+ 2.767000000000e-06 1.692182470576e-01
+ 2.768000000000e-06 1.692792262728e-01
+ 2.769000000000e-06 1.693402054880e-01
+ 2.770000000000e-06 1.694011847032e-01
+ 2.771000000000e-06 1.694621639185e-01
+ 2.772000000000e-06 1.695231431337e-01
+ 2.773000000000e-06 1.695841223489e-01
+ 2.774000000000e-06 1.696451015641e-01
+ 2.775000000000e-06 1.697060807793e-01
+ 2.776000000000e-06 1.697670599945e-01
+ 2.777000000000e-06 1.698280392098e-01
+ 2.778000000000e-06 1.698890184250e-01
+ 2.779000000000e-06 1.699499976402e-01
+ 2.780000000000e-06 1.700109768554e-01
+ 2.781000000000e-06 1.700719560706e-01
+ 2.782000000000e-06 1.701329352858e-01
+ 2.783000000000e-06 1.701939145011e-01
+ 2.784000000000e-06 1.702548937163e-01
+ 2.785000000000e-06 1.703158729315e-01
+ 2.786000000000e-06 1.703768521467e-01
+ 2.787000000000e-06 1.704378313619e-01
+ 2.788000000000e-06 1.704988105771e-01
+ 2.789000000000e-06 1.705597897924e-01
+ 2.790000000000e-06 1.706207690076e-01
+ 2.791000000000e-06 1.706817482228e-01
+ 2.792000000000e-06 1.707427274380e-01
+ 2.793000000000e-06 1.708037066532e-01
+ 2.794000000000e-06 1.708646858684e-01
+ 2.795000000000e-06 1.709256650837e-01
+ 2.796000000000e-06 1.709866442989e-01
+ 2.797000000000e-06 1.710476235141e-01
+ 2.798000000000e-06 1.711086027293e-01
+ 2.799000000000e-06 1.711695819445e-01
+ 2.800000000000e-06 1.712305611597e-01
+ 2.801000000000e-06 1.712915403750e-01
+ 2.802000000000e-06 1.713525195902e-01
+ 2.803000000000e-06 1.714134988054e-01
+ 2.804000000000e-06 1.714744780206e-01
+ 2.805000000000e-06 1.715354572358e-01
+ 2.806000000000e-06 1.715964364510e-01
+ 2.807000000000e-06 1.716574156663e-01
+ 2.808000000000e-06 1.717183948815e-01
+ 2.809000000000e-06 1.717793740967e-01
+ 2.810000000000e-06 1.718403533119e-01
+ 2.811000000000e-06 1.719013325271e-01
+ 2.812000000000e-06 1.719623117423e-01
+ 2.813000000000e-06 1.720232909576e-01
+ 2.814000000000e-06 1.720842701728e-01
+ 2.815000000000e-06 1.721452493880e-01
+ 2.816000000000e-06 1.722062286032e-01
+ 2.817000000000e-06 1.722672078184e-01
+ 2.818000000000e-06 1.723281870336e-01
+ 2.819000000000e-06 1.723891662489e-01
+ 2.820000000000e-06 1.724501454641e-01
+ 2.821000000000e-06 1.725111246793e-01
+ 2.822000000000e-06 1.725721038945e-01
+ 2.823000000000e-06 1.726330831097e-01
+ 2.824000000000e-06 1.726940623249e-01
+ 2.825000000000e-06 1.727550415402e-01
+ 2.826000000000e-06 1.728160207554e-01
+ 2.827000000000e-06 1.728769999706e-01
+ 2.828000000000e-06 1.729379791858e-01
+ 2.829000000000e-06 1.729989584010e-01
+ 2.830000000000e-06 1.730599376162e-01
+ 2.831000000000e-06 1.731209168315e-01
+ 2.832000000000e-06 1.731818960467e-01
+ 2.833000000000e-06 1.732428752619e-01
+ 2.834000000000e-06 1.733038544771e-01
+ 2.835000000000e-06 1.733648336923e-01
+ 2.836000000000e-06 1.734258129075e-01
+ 2.837000000000e-06 1.734867921228e-01
+ 2.838000000000e-06 1.735477713380e-01
+ 2.839000000000e-06 1.736087505532e-01
+ 2.840000000000e-06 1.736697297684e-01
+ 2.841000000000e-06 1.737307089836e-01
+ 2.842000000000e-06 1.737916881988e-01
+ 2.843000000000e-06 1.738526674140e-01
+ 2.844000000000e-06 1.739136466293e-01
+ 2.845000000000e-06 1.739746258445e-01
+ 2.846000000000e-06 1.740356050597e-01
+ 2.847000000000e-06 1.740965842749e-01
+ 2.848000000000e-06 1.741575634901e-01
+ 2.849000000000e-06 1.742185427053e-01
+ 2.850000000000e-06 1.742795219206e-01
+ 2.851000000000e-06 1.743405011358e-01
+ 2.852000000000e-06 1.744014803510e-01
+ 2.853000000000e-06 1.744624595662e-01
+ 2.854000000000e-06 1.745234387814e-01
+ 2.855000000000e-06 1.745844179966e-01
+ 2.856000000000e-06 1.746453972119e-01
+ 2.857000000000e-06 1.747063764271e-01
+ 2.858000000000e-06 1.747673556423e-01
+ 2.859000000000e-06 1.748283348575e-01
+ 2.860000000000e-06 1.748893140727e-01
+ 2.861000000000e-06 1.749502932879e-01
+ 2.862000000000e-06 1.750112725032e-01
+ 2.863000000000e-06 1.750722517184e-01
+ 2.864000000000e-06 1.751332309336e-01
+ 2.865000000000e-06 1.751942101488e-01
+ 2.866000000000e-06 1.752551893640e-01
+ 2.867000000000e-06 1.753161685792e-01
+ 2.868000000000e-06 1.753771477945e-01
+ 2.869000000000e-06 1.754381270097e-01
+ 2.870000000000e-06 1.754991062249e-01
+ 2.871000000000e-06 1.755600854401e-01
+ 2.872000000000e-06 1.756210646553e-01
+ 2.873000000000e-06 1.756820438705e-01
+ 2.874000000000e-06 1.757430230858e-01
+ 2.875000000000e-06 1.758040023010e-01
+ 2.876000000000e-06 1.758649815162e-01
+ 2.877000000000e-06 1.759259607314e-01
+ 2.878000000000e-06 1.759869399466e-01
+ 2.879000000000e-06 1.760479191618e-01
+ 2.880000000000e-06 1.761088983771e-01
+ 2.881000000000e-06 1.761698775923e-01
+ 2.882000000000e-06 1.762308568075e-01
+ 2.883000000000e-06 1.762918360227e-01
+ 2.884000000000e-06 1.763528152379e-01
+ 2.885000000000e-06 1.764137944531e-01
+ 2.886000000000e-06 1.764747736684e-01
+ 2.887000000000e-06 1.765357528836e-01
+ 2.888000000000e-06 1.765967320988e-01
+ 2.889000000000e-06 1.766577113140e-01
+ 2.890000000000e-06 1.767186905292e-01
+ 2.891000000000e-06 1.767796697444e-01
+ 2.892000000000e-06 1.768406489597e-01
+ 2.893000000000e-06 1.769016281749e-01
+ 2.894000000000e-06 1.769626073901e-01
+ 2.895000000000e-06 1.770235866053e-01
+ 2.896000000000e-06 1.770845658205e-01
+ 2.897000000000e-06 1.771455450357e-01
+ 2.898000000000e-06 1.772065242510e-01
+ 2.899000000000e-06 1.772675034662e-01
+ 2.900000000000e-06 1.773284826814e-01
+ 2.901000000000e-06 1.773894618966e-01
+ 2.902000000000e-06 1.774504411118e-01
+ 2.903000000000e-06 1.775114203270e-01
+ 2.904000000000e-06 1.775723995423e-01
+ 2.905000000000e-06 1.776333787575e-01
+ 2.906000000000e-06 1.776943579727e-01
+ 2.907000000000e-06 1.777553371879e-01
+ 2.908000000000e-06 1.778163164031e-01
+ 2.909000000000e-06 1.778772956183e-01
+ 2.910000000000e-06 1.779382748336e-01
+ 2.911000000000e-06 1.779992540488e-01
+ 2.912000000000e-06 1.780602332640e-01
+ 2.913000000000e-06 1.781212124792e-01
+ 2.914000000000e-06 1.781821916944e-01
+ 2.915000000000e-06 1.782431709096e-01
+ 2.916000000000e-06 1.783041501249e-01
+ 2.917000000000e-06 1.783651293401e-01
+ 2.918000000000e-06 1.784261085553e-01
+ 2.919000000000e-06 1.784870877705e-01
+ 2.920000000000e-06 1.785480669857e-01
+ 2.921000000000e-06 1.786090462009e-01
+ 2.922000000000e-06 1.786700254162e-01
+ 2.923000000000e-06 1.787310046314e-01
+ 2.924000000000e-06 1.787919838466e-01
+ 2.925000000000e-06 1.788529630618e-01
+ 2.926000000000e-06 1.789139422770e-01
+ 2.927000000000e-06 1.789749214922e-01
+ 2.928000000000e-06 1.790359007075e-01
+ 2.929000000000e-06 1.790968799227e-01
+ 2.930000000000e-06 1.791578591379e-01
+ 2.931000000000e-06 1.792188383531e-01
+ 2.932000000000e-06 1.792798175683e-01
+ 2.933000000000e-06 1.793407967835e-01
+ 2.934000000000e-06 1.794017759988e-01
+ 2.935000000000e-06 1.794627552140e-01
+ 2.936000000000e-06 1.795237344292e-01
+ 2.937000000000e-06 1.795847136444e-01
+ 2.938000000000e-06 1.796456928596e-01
+ 2.939000000000e-06 1.797066720748e-01
+ 2.940000000000e-06 1.797676512901e-01
+ 2.941000000000e-06 1.798286305053e-01
+ 2.942000000000e-06 1.798896097205e-01
+ 2.943000000000e-06 1.799505889357e-01
+ 2.944000000000e-06 1.800115681509e-01
+ 2.945000000000e-06 1.800725473661e-01
+ 2.946000000000e-06 1.801335265814e-01
+ 2.947000000000e-06 1.801945057966e-01
+ 2.948000000000e-06 1.802554850118e-01
+ 2.949000000000e-06 1.803164642270e-01
+ 2.950000000000e-06 1.803774434422e-01
+ 2.951000000000e-06 1.804384226574e-01
+ 2.952000000000e-06 1.804994018727e-01
+ 2.953000000000e-06 1.805603810879e-01
+ 2.954000000000e-06 1.806213603031e-01
+ 2.955000000000e-06 1.806823395183e-01
+ 2.956000000000e-06 1.807433187335e-01
+ 2.957000000000e-06 1.808042979487e-01
+ 2.958000000000e-06 1.808652771640e-01
+ 2.959000000000e-06 1.809262563792e-01
+ 2.960000000000e-06 1.809872355944e-01
+ 2.961000000000e-06 1.810482148096e-01
+ 2.962000000000e-06 1.811091940248e-01
+ 2.963000000000e-06 1.811701732400e-01
+ 2.964000000000e-06 1.812311524553e-01
+ 2.965000000000e-06 1.812921316705e-01
+ 2.966000000000e-06 1.813531108857e-01
+ 2.967000000000e-06 1.814140901009e-01
+ 2.968000000000e-06 1.814750693161e-01
+ 2.969000000000e-06 1.815360485313e-01
+ 2.970000000000e-06 1.815970277466e-01
+ 2.971000000000e-06 1.816580069618e-01
+ 2.972000000000e-06 1.817189861770e-01
+ 2.973000000000e-06 1.817799653922e-01
+ 2.974000000000e-06 1.818409446074e-01
+ 2.975000000000e-06 1.819019238226e-01
+ 2.976000000000e-06 1.819629030379e-01
+ 2.977000000000e-06 1.820238822531e-01
+ 2.978000000000e-06 1.820848614683e-01
+ 2.979000000000e-06 1.821458406835e-01
+ 2.980000000000e-06 1.822068198987e-01
+ 2.981000000000e-06 1.822677991139e-01
+ 2.982000000000e-06 1.823287783292e-01
+ 2.983000000000e-06 1.823897575444e-01
+ 2.984000000000e-06 1.824507367596e-01
+ 2.985000000000e-06 1.825117159748e-01
+ 2.986000000000e-06 1.825726951900e-01
+ 2.987000000000e-06 1.826336744052e-01
+ 2.988000000000e-06 1.826946536205e-01
+ 2.989000000000e-06 1.827556328357e-01
+ 2.990000000000e-06 1.828166120509e-01
+ 2.991000000000e-06 1.828775912661e-01
+ 2.992000000000e-06 1.829385704813e-01
+ 2.993000000000e-06 1.829995496965e-01
+ 2.994000000000e-06 1.830605289118e-01
+ 2.995000000000e-06 1.831215081270e-01
+ 2.996000000000e-06 1.831824873422e-01
+ 2.997000000000e-06 1.832434665574e-01
+ 2.998000000000e-06 1.833044457726e-01
+ 2.999000000000e-06 1.833654249878e-01
+ 3.000000000000e-06 1.834264042031e-01
+ 3.001000000000e-06 1.834873834183e-01
+ 3.002000000000e-06 1.835483626335e-01
+ 3.003000000000e-06 1.836093418487e-01
+ 3.004000000000e-06 1.836703210639e-01
+ 3.005000000000e-06 1.837313002791e-01
+ 3.006000000000e-06 1.837922794944e-01
+ 3.007000000000e-06 1.838532587096e-01
+ 3.008000000000e-06 1.839142379248e-01
+ 3.009000000000e-06 1.839752171400e-01
+ 3.010000000000e-06 1.840361963552e-01
+ 3.011000000000e-06 1.840971755704e-01
+ 3.012000000000e-06 1.841581547857e-01
+ 3.013000000000e-06 1.842191340009e-01
+ 3.014000000000e-06 1.842801132161e-01
+ 3.015000000000e-06 1.843410924313e-01
+ 3.016000000000e-06 1.844020716465e-01
+ 3.017000000000e-06 1.844630508617e-01
+ 3.018000000000e-06 1.845240300770e-01
+ 3.019000000000e-06 1.845850092922e-01
+ 3.020000000000e-06 1.846459885074e-01
+ 3.021000000000e-06 1.847069677226e-01
+ 3.022000000000e-06 1.847679469378e-01
+ 3.023000000000e-06 1.848289261530e-01
+ 3.024000000000e-06 1.848899053683e-01
+ 3.025000000000e-06 1.849508845835e-01
+ 3.026000000000e-06 1.850118637987e-01
+ 3.027000000000e-06 1.850728430139e-01
+ 3.028000000000e-06 1.851338222291e-01
+ 3.029000000000e-06 1.851948014443e-01
+ 3.030000000000e-06 1.852557806596e-01
+ 3.031000000000e-06 1.853167598748e-01
+ 3.032000000000e-06 1.853777390900e-01
+ 3.033000000000e-06 1.854387183052e-01
+ 3.034000000000e-06 1.854996975204e-01
+ 3.035000000000e-06 1.855606767356e-01
+ 3.036000000000e-06 1.856216559509e-01
+ 3.037000000000e-06 1.856826351661e-01
+ 3.038000000000e-06 1.857436143813e-01
+ 3.039000000000e-06 1.858045935965e-01
+ 3.040000000000e-06 1.858655728117e-01
+ 3.041000000000e-06 1.859265520269e-01
+ 3.042000000000e-06 1.859875312422e-01
+ 3.043000000000e-06 1.860485104574e-01
+ 3.044000000000e-06 1.861094896726e-01
+ 3.045000000000e-06 1.861704688878e-01
+ 3.046000000000e-06 1.862314481030e-01
+ 3.047000000000e-06 1.862924273182e-01
+ 3.048000000000e-06 1.863534065335e-01
+ 3.049000000000e-06 1.864143857487e-01
+ 3.050000000000e-06 1.864753649639e-01
+ 3.051000000000e-06 1.865363441791e-01
+ 3.052000000000e-06 1.865973233943e-01
+ 3.053000000000e-06 1.866583026095e-01
+ 3.054000000000e-06 1.867192818248e-01
+ 3.055000000000e-06 1.867802610400e-01
+ 3.056000000000e-06 1.868412402552e-01
+ 3.057000000000e-06 1.869022194704e-01
+ 3.058000000000e-06 1.869631986856e-01
+ 3.059000000000e-06 1.870241779008e-01
+ 3.060000000000e-06 1.870851571161e-01
+ 3.061000000000e-06 1.871461363313e-01
+ 3.062000000000e-06 1.872071155465e-01
+ 3.063000000000e-06 1.872680947617e-01
+ 3.064000000000e-06 1.873290739769e-01
+ 3.065000000000e-06 1.873900531921e-01
+ 3.066000000000e-06 1.874510324074e-01
+ 3.067000000000e-06 1.875120116226e-01
+ 3.068000000000e-06 1.875729908378e-01
+ 3.069000000000e-06 1.876339700530e-01
+ 3.070000000000e-06 1.876949492682e-01
+ 3.071000000000e-06 1.877559284834e-01
+ 3.072000000000e-06 1.878169076986e-01
+ 3.073000000000e-06 1.878778869139e-01
+ 3.074000000000e-06 1.879388661291e-01
+ 3.075000000000e-06 1.879998453443e-01
+ 3.076000000000e-06 1.880608245595e-01
+ 3.077000000000e-06 1.881218037747e-01
+ 3.078000000000e-06 1.881827829899e-01
+ 3.079000000000e-06 1.882437622052e-01
+ 3.080000000000e-06 1.883047414204e-01
+ 3.081000000000e-06 1.883657206356e-01
+ 3.082000000000e-06 1.884266998508e-01
+ 3.083000000000e-06 1.884876790660e-01
+ 3.084000000000e-06 1.885486582812e-01
+ 3.085000000000e-06 1.886096374965e-01
+ 3.086000000000e-06 1.886706167117e-01
+ 3.087000000000e-06 1.887315959269e-01
+ 3.088000000000e-06 1.887925751421e-01
+ 3.089000000000e-06 1.888535543573e-01
+ 3.090000000000e-06 1.889145335725e-01
+ 3.091000000000e-06 1.889755127878e-01
+ 3.092000000000e-06 1.890364920030e-01
+ 3.093000000000e-06 1.890974712182e-01
+ 3.094000000000e-06 1.891584504334e-01
+ 3.095000000000e-06 1.892194296486e-01
+ 3.096000000000e-06 1.892804088638e-01
+ 3.097000000000e-06 1.893413880791e-01
+ 3.098000000000e-06 1.894023672943e-01
+ 3.099000000000e-06 1.894633465095e-01
+ 3.100000000000e-06 1.895243257247e-01
+ 3.101000000000e-06 1.895853049399e-01
+ 3.102000000000e-06 1.896462841551e-01
+ 3.103000000000e-06 1.897072633704e-01
+ 3.104000000000e-06 1.897682425856e-01
+ 3.105000000000e-06 1.898292218008e-01
+ 3.106000000000e-06 1.898902010160e-01
+ 3.107000000000e-06 1.899511802312e-01
+ 3.108000000000e-06 1.900121594464e-01
+ 3.109000000000e-06 1.900731386617e-01
+ 3.110000000000e-06 1.901341178769e-01
+ 3.111000000000e-06 1.901950970921e-01
+ 3.112000000000e-06 1.902560763073e-01
+ 3.113000000000e-06 1.903170555225e-01
+ 3.114000000000e-06 1.903780347377e-01
+ 3.115000000000e-06 1.904390139530e-01
+ 3.116000000000e-06 1.904999931682e-01
+ 3.117000000000e-06 1.905609723834e-01
+ 3.118000000000e-06 1.906219515986e-01
+ 3.119000000000e-06 1.906829308138e-01
+ 3.120000000000e-06 1.907439100290e-01
+ 3.121000000000e-06 1.908048892443e-01
+ 3.122000000000e-06 1.908658684595e-01
+ 3.123000000000e-06 1.909268476747e-01
+ 3.124000000000e-06 1.909878268899e-01
+ 3.125000000000e-06 1.910488061051e-01
+ 3.126000000000e-06 1.911097853203e-01
+ 3.127000000000e-06 1.911707645356e-01
+ 3.128000000000e-06 1.912317437508e-01
+ 3.129000000000e-06 1.912927229660e-01
+ 3.130000000000e-06 1.913537021812e-01
+ 3.131000000000e-06 1.914146813964e-01
+ 3.132000000000e-06 1.914756606116e-01
+ 3.133000000000e-06 1.915366398269e-01
+ 3.134000000000e-06 1.915976190421e-01
+ 3.135000000000e-06 1.916585982573e-01
+ 3.136000000000e-06 1.917195774725e-01
+ 3.137000000000e-06 1.917805566877e-01
+ 3.138000000000e-06 1.918415359029e-01
+ 3.139000000000e-06 1.919025151182e-01
+ 3.140000000000e-06 1.919634943334e-01
+ 3.141000000000e-06 1.920244735486e-01
+ 3.142000000000e-06 1.920854527638e-01
+ 3.143000000000e-06 1.921464319790e-01
+ 3.144000000000e-06 1.922074111942e-01
+ 3.145000000000e-06 1.922683904095e-01
+ 3.146000000000e-06 1.923293696247e-01
+ 3.147000000000e-06 1.923903488399e-01
+ 3.148000000000e-06 1.924513280551e-01
+ 3.149000000000e-06 1.925123072703e-01
+ 3.150000000000e-06 1.925732864855e-01
+ 3.151000000000e-06 1.926342657008e-01
+ 3.152000000000e-06 1.926952449160e-01
+ 3.153000000000e-06 1.927562241312e-01
+ 3.154000000000e-06 1.928172033464e-01
+ 3.155000000000e-06 1.928781825616e-01
+ 3.156000000000e-06 1.929391617768e-01
+ 3.157000000000e-06 1.930001409921e-01
+ 3.158000000000e-06 1.930611202073e-01
+ 3.159000000000e-06 1.931220994225e-01
+ 3.160000000000e-06 1.931830786377e-01
+ 3.161000000000e-06 1.932440578529e-01
+ 3.162000000000e-06 1.933050370681e-01
+ 3.163000000000e-06 1.933660162834e-01
+ 3.164000000000e-06 1.934269954986e-01
+ 3.165000000000e-06 1.934879747138e-01
+ 3.166000000000e-06 1.935489539290e-01
+ 3.167000000000e-06 1.936099331442e-01
+ 3.168000000000e-06 1.936709123594e-01
+ 3.169000000000e-06 1.937318915747e-01
+ 3.170000000000e-06 1.937928707899e-01
+ 3.171000000000e-06 1.938538500051e-01
+ 3.172000000000e-06 1.939148292203e-01
+ 3.173000000000e-06 1.939758084355e-01
+ 3.174000000000e-06 1.940367876507e-01
+ 3.175000000000e-06 1.940977668660e-01
+ 3.176000000000e-06 1.941587460812e-01
+ 3.177000000000e-06 1.942197252964e-01
+ 3.178000000000e-06 1.942807045116e-01
+ 3.179000000000e-06 1.943416837268e-01
+ 3.180000000000e-06 1.944026629420e-01
+ 3.181000000000e-06 1.944636421573e-01
+ 3.182000000000e-06 1.945246213725e-01
+ 3.183000000000e-06 1.945856005877e-01
+ 3.184000000000e-06 1.946465798029e-01
+ 3.185000000000e-06 1.947075590181e-01
+ 3.186000000000e-06 1.947685382333e-01
+ 3.187000000000e-06 1.948295174486e-01
+ 3.188000000000e-06 1.948904966638e-01
+ 3.189000000000e-06 1.949514758790e-01
+ 3.190000000000e-06 1.950124550942e-01
+ 3.191000000000e-06 1.950734343094e-01
+ 3.192000000000e-06 1.951344135246e-01
+ 3.193000000000e-06 1.951953927399e-01
+ 3.194000000000e-06 1.952563719551e-01
+ 3.195000000000e-06 1.953173511703e-01
+ 3.196000000000e-06 1.953783303855e-01
+ 3.197000000000e-06 1.954393096007e-01
+ 3.198000000000e-06 1.955002888159e-01
+ 3.199000000000e-06 1.955612680312e-01
+ 3.200000000000e-06 1.956222472464e-01
+ 3.201000000000e-06 1.956832264616e-01
+ 3.202000000000e-06 1.957442056768e-01
+ 3.203000000000e-06 1.958051848920e-01
+ 3.204000000000e-06 1.958661641072e-01
+ 3.205000000000e-06 1.959271433225e-01
+ 3.206000000000e-06 1.959881225377e-01
+ 3.207000000000e-06 1.960491017529e-01
+ 3.208000000000e-06 1.961100809681e-01
+ 3.209000000000e-06 1.961710601833e-01
+ 3.210000000000e-06 1.962320393985e-01
+ 3.211000000000e-06 1.962930186138e-01
+ 3.212000000000e-06 1.963539978290e-01
+ 3.213000000000e-06 1.964149770442e-01
+ 3.214000000000e-06 1.964759562594e-01
+ 3.215000000000e-06 1.965369354746e-01
+ 3.216000000000e-06 1.965979146898e-01
+ 3.217000000000e-06 1.966588939051e-01
+ 3.218000000000e-06 1.967198731203e-01
+ 3.219000000000e-06 1.967808523355e-01
+ 3.220000000000e-06 1.968418315507e-01
+ 3.221000000000e-06 1.969028107659e-01
+ 3.222000000000e-06 1.969637899811e-01
+ 3.223000000000e-06 1.970247691964e-01
+ 3.224000000000e-06 1.970857484116e-01
+ 3.225000000000e-06 1.971467276268e-01
+ 3.226000000000e-06 1.972077068420e-01
+ 3.227000000000e-06 1.972686860572e-01
+ 3.228000000000e-06 1.973296652724e-01
+ 3.229000000000e-06 1.973906444877e-01
+ 3.230000000000e-06 1.974516237029e-01
+ 3.231000000000e-06 1.975126029181e-01
+ 3.232000000000e-06 1.975735821333e-01
+ 3.233000000000e-06 1.976345613485e-01
+ 3.234000000000e-06 1.976955405637e-01
+ 3.235000000000e-06 1.977565197790e-01
+ 3.236000000000e-06 1.978174989942e-01
+ 3.237000000000e-06 1.978784782094e-01
+ 3.238000000000e-06 1.979394574246e-01
+ 3.239000000000e-06 1.980004366398e-01
+ 3.240000000000e-06 1.980614158550e-01
+ 3.241000000000e-06 1.981223950703e-01
+ 3.242000000000e-06 1.981833742855e-01
+ 3.243000000000e-06 1.982443535007e-01
+ 3.244000000000e-06 1.983053327159e-01
+ 3.245000000000e-06 1.983663119311e-01
+ 3.246000000000e-06 1.984272911463e-01
+ 3.247000000000e-06 1.984882703616e-01
+ 3.248000000000e-06 1.985492495768e-01
+ 3.249000000000e-06 1.986102287920e-01
+ 3.250000000000e-06 1.986712080072e-01
+ 3.251000000000e-06 1.987321872224e-01
+ 3.252000000000e-06 1.987931664376e-01
+ 3.253000000000e-06 1.988541456529e-01
+ 3.254000000000e-06 1.989151248681e-01
+ 3.255000000000e-06 1.989761040833e-01
+ 3.256000000000e-06 1.990370832985e-01
+ 3.257000000000e-06 1.990980625137e-01
+ 3.258000000000e-06 1.991590417289e-01
+ 3.259000000000e-06 1.992200209442e-01
+ 3.260000000000e-06 1.992810001594e-01
+ 3.261000000000e-06 1.993419793746e-01
+ 3.262000000000e-06 1.994029585898e-01
+ 3.263000000000e-06 1.994639378050e-01
+ 3.264000000000e-06 1.995249170202e-01
+ 3.265000000000e-06 1.995858962355e-01
+ 3.266000000000e-06 1.996468754507e-01
+ 3.267000000000e-06 1.997078546659e-01
+ 3.268000000000e-06 1.997688338811e-01
+ 3.269000000000e-06 1.998298130963e-01
+ 3.270000000000e-06 1.998907923115e-01
+ 3.271000000000e-06 1.999517715268e-01
+ 3.272000000000e-06 2.000127507420e-01
+ 3.273000000000e-06 2.000737299572e-01
+ 3.274000000000e-06 2.001347091724e-01
+ 3.275000000000e-06 2.001956883876e-01
+ 3.276000000000e-06 2.002566676028e-01
+ 3.277000000000e-06 2.003176468181e-01
+ 3.278000000000e-06 2.003786260333e-01
+ 3.279000000000e-06 2.004396052485e-01
+ 3.280000000000e-06 2.005005844637e-01
+ 3.281000000000e-06 2.005615636789e-01
+ 3.282000000000e-06 2.006225428941e-01
+ 3.283000000000e-06 2.006835221094e-01
+ 3.284000000000e-06 2.007445013246e-01
+ 3.285000000000e-06 2.008054805398e-01
+ 3.286000000000e-06 2.008664597550e-01
+ 3.287000000000e-06 2.009274389702e-01
+ 3.288000000000e-06 2.009884181854e-01
+ 3.289000000000e-06 2.010493974007e-01
+ 3.290000000000e-06 2.011103766159e-01
+ 3.291000000000e-06 2.011713558311e-01
+ 3.292000000000e-06 2.012323350463e-01
+ 3.293000000000e-06 2.012933142615e-01
+ 3.294000000000e-06 2.013542934767e-01
+ 3.295000000000e-06 2.014152726920e-01
+ 3.296000000000e-06 2.014762519072e-01
+ 3.297000000000e-06 2.015372311224e-01
+ 3.298000000000e-06 2.015982103376e-01
+ 3.299000000000e-06 2.016591895528e-01
+ 3.300000000000e-06 2.017201687680e-01
+ 3.301000000000e-06 2.017811479832e-01
+ 3.302000000000e-06 2.018421271985e-01
+ 3.303000000000e-06 2.019031064137e-01
+ 3.304000000000e-06 2.019640856289e-01
+ 3.305000000000e-06 2.020250648441e-01
+ 3.306000000000e-06 2.020860440593e-01
+ 3.307000000000e-06 2.021470232745e-01
+ 3.308000000000e-06 2.022080024898e-01
+ 3.309000000000e-06 2.022689817050e-01
+ 3.310000000000e-06 2.023299609202e-01
+ 3.311000000000e-06 2.023909401354e-01
+ 3.312000000000e-06 2.024519193506e-01
+ 3.313000000000e-06 2.025128985658e-01
+ 3.314000000000e-06 2.025738777811e-01
+ 3.315000000000e-06 2.026348569963e-01
+ 3.316000000000e-06 2.026958362115e-01
+ 3.317000000000e-06 2.027568154267e-01
+ 3.318000000000e-06 2.028177946419e-01
+ 3.319000000000e-06 2.028787738571e-01
+ 3.320000000000e-06 2.029397530724e-01
+ 3.321000000000e-06 2.030007322876e-01
+ 3.322000000000e-06 2.030617115028e-01
+ 3.323000000000e-06 2.031226907180e-01
+ 3.324000000000e-06 2.031836699332e-01
+ 3.325000000000e-06 2.032446491484e-01
+ 3.326000000000e-06 2.033056283637e-01
+ 3.327000000000e-06 2.033666075789e-01
+ 3.328000000000e-06 2.034275867941e-01
+ 3.329000000000e-06 2.034885660093e-01
+ 3.330000000000e-06 2.035495452245e-01
+ 3.331000000000e-06 2.036105244397e-01
+ 3.332000000000e-06 2.036715036550e-01
+ 3.333000000000e-06 2.037324828702e-01
+ 3.334000000000e-06 2.037934620854e-01
+ 3.335000000000e-06 2.038544413006e-01
+ 3.336000000000e-06 2.039154205158e-01
+ 3.337000000000e-06 2.039763997310e-01
+ 3.338000000000e-06 2.040373789463e-01
+ 3.339000000000e-06 2.040983581615e-01
+ 3.340000000000e-06 2.041593373767e-01
+ 3.341000000000e-06 2.042203165919e-01
+ 3.342000000000e-06 2.042812958071e-01
+ 3.343000000000e-06 2.043422750223e-01
+ 3.344000000000e-06 2.044032542376e-01
+ 3.345000000000e-06 2.044642334528e-01
+ 3.346000000000e-06 2.045252126680e-01
+ 3.347000000000e-06 2.045861918832e-01
+ 3.348000000000e-06 2.046471710984e-01
+ 3.349000000000e-06 2.047081503136e-01
+ 3.350000000000e-06 2.047691295289e-01
+ 3.351000000000e-06 2.048301087441e-01
+ 3.352000000000e-06 2.048910879593e-01
+ 3.353000000000e-06 2.049520671745e-01
+ 3.354000000000e-06 2.050130463897e-01
+ 3.355000000000e-06 2.050740256049e-01
+ 3.356000000000e-06 2.051350048202e-01
+ 3.357000000000e-06 2.051959840354e-01
+ 3.358000000000e-06 2.052569632506e-01
+ 3.359000000000e-06 2.053179424658e-01
+ 3.360000000000e-06 2.053789216810e-01
+ 3.361000000000e-06 2.054399008962e-01
+ 3.362000000000e-06 2.055008801115e-01
+ 3.363000000000e-06 2.055618593267e-01
+ 3.364000000000e-06 2.056228385419e-01
+ 3.365000000000e-06 2.056838177571e-01
+ 3.366000000000e-06 2.057447969723e-01
+ 3.367000000000e-06 2.058057761875e-01
+ 3.368000000000e-06 2.058667554028e-01
+ 3.369000000000e-06 2.059277346180e-01
+ 3.370000000000e-06 2.059887138332e-01
+ 3.371000000000e-06 2.060496930484e-01
+ 3.372000000000e-06 2.061106722636e-01
+ 3.373000000000e-06 2.061716514788e-01
+ 3.374000000000e-06 2.062326306941e-01
+ 3.375000000000e-06 2.062936099093e-01
+ 3.376000000000e-06 2.063545891245e-01
+ 3.377000000000e-06 2.064155683397e-01
+ 3.378000000000e-06 2.064765475549e-01
+ 3.379000000000e-06 2.065375267701e-01
+ 3.380000000000e-06 2.065985059854e-01
+ 3.381000000000e-06 2.066594852006e-01
+ 3.382000000000e-06 2.067204644158e-01
+ 3.383000000000e-06 2.067814436310e-01
+ 3.384000000000e-06 2.068424228462e-01
+ 3.385000000000e-06 2.069034020614e-01
+ 3.386000000000e-06 2.069643812767e-01
+ 3.387000000000e-06 2.070253604919e-01
+ 3.388000000000e-06 2.070863397071e-01
+ 3.389000000000e-06 2.071473189223e-01
+ 3.390000000000e-06 2.072082981375e-01
+ 3.391000000000e-06 2.072692773527e-01
+ 3.392000000000e-06 2.073302565680e-01
+ 3.393000000000e-06 2.073912357832e-01
+ 3.394000000000e-06 2.074522149984e-01
+ 3.395000000000e-06 2.075131942136e-01
+ 3.396000000000e-06 2.075741734288e-01
+ 3.397000000000e-06 2.076351526440e-01
+ 3.398000000000e-06 2.076961318593e-01
+ 3.399000000000e-06 2.077571110745e-01
+ 3.400000000000e-06 2.078180902897e-01
+ 3.401000000000e-06 2.078790695049e-01
+ 3.402000000000e-06 2.079400487201e-01
+ 3.403000000000e-06 2.080010279353e-01
+ 3.404000000000e-06 2.080620071506e-01
+ 3.405000000000e-06 2.081229863658e-01
+ 3.406000000000e-06 2.081839655810e-01
+ 3.407000000000e-06 2.082449447962e-01
+ 3.408000000000e-06 2.083059240114e-01
+ 3.409000000000e-06 2.083669032266e-01
+ 3.410000000000e-06 2.084278824419e-01
+ 3.411000000000e-06 2.084888616571e-01
+ 3.412000000000e-06 2.085498408723e-01
+ 3.413000000000e-06 2.086108200875e-01
+ 3.414000000000e-06 2.086717993027e-01
+ 3.415000000000e-06 2.087327785179e-01
+ 3.416000000000e-06 2.087937577332e-01
+ 3.417000000000e-06 2.088547369484e-01
+ 3.418000000000e-06 2.089157161636e-01
+ 3.419000000000e-06 2.089766953788e-01
+ 3.420000000000e-06 2.090376745940e-01
+ 3.421000000000e-06 2.090986538092e-01
+ 3.422000000000e-06 2.091596330245e-01
+ 3.423000000000e-06 2.092206122397e-01
+ 3.424000000000e-06 2.092815914549e-01
+ 3.425000000000e-06 2.093425706701e-01
+ 3.426000000000e-06 2.094035498853e-01
+ 3.427000000000e-06 2.094645291005e-01
+ 3.428000000000e-06 2.095255083158e-01
+ 3.429000000000e-06 2.095864875310e-01
+ 3.430000000000e-06 2.096474667462e-01
+ 3.431000000000e-06 2.097084459614e-01
+ 3.432000000000e-06 2.097694251766e-01
+ 3.433000000000e-06 2.098304043918e-01
+ 3.434000000000e-06 2.098913836071e-01
+ 3.435000000000e-06 2.099523628223e-01
+ 3.436000000000e-06 2.100133420375e-01
+ 3.437000000000e-06 2.100743212527e-01
+ 3.438000000000e-06 2.101353004679e-01
+ 3.439000000000e-06 2.101962796831e-01
+ 3.440000000000e-06 2.102572588984e-01
+ 3.441000000000e-06 2.103182381136e-01
+ 3.442000000000e-06 2.103792173288e-01
+ 3.443000000000e-06 2.104401965440e-01
+ 3.444000000000e-06 2.105011757592e-01
+ 3.445000000000e-06 2.105621549744e-01
+ 3.446000000000e-06 2.106231341897e-01
+ 3.447000000000e-06 2.106841134049e-01
+ 3.448000000000e-06 2.107450926201e-01
+ 3.449000000000e-06 2.108060718353e-01
+ 3.450000000000e-06 2.108670510505e-01
+ 3.451000000000e-06 2.109280302657e-01
+ 3.452000000000e-06 2.109890094810e-01
+ 3.453000000000e-06 2.110499886962e-01
+ 3.454000000000e-06 2.111109679114e-01
+ 3.455000000000e-06 2.111719471266e-01
+ 3.456000000000e-06 2.112329263418e-01
+ 3.457000000000e-06 2.112939055570e-01
+ 3.458000000000e-06 2.113548847723e-01
+ 3.459000000000e-06 2.114158639875e-01
+ 3.460000000000e-06 2.114768432027e-01
+ 3.461000000000e-06 2.115378224179e-01
+ 3.462000000000e-06 2.115988016331e-01
+ 3.463000000000e-06 2.116597808483e-01
+ 3.464000000000e-06 2.117207600636e-01
+ 3.465000000000e-06 2.117817392788e-01
+ 3.466000000000e-06 2.118427184940e-01
+ 3.467000000000e-06 2.119036977092e-01
+ 3.468000000000e-06 2.119646769244e-01
+ 3.469000000000e-06 2.120256561396e-01
+ 3.470000000000e-06 2.120866353549e-01
+ 3.471000000000e-06 2.121476145701e-01
+ 3.472000000000e-06 2.122085937853e-01
+ 3.473000000000e-06 2.122695730005e-01
+ 3.474000000000e-06 2.123305522157e-01
+ 3.475000000000e-06 2.123915314309e-01
+ 3.476000000000e-06 2.124525106462e-01
+ 3.477000000000e-06 2.125134898614e-01
+ 3.478000000000e-06 2.125744690766e-01
+ 3.479000000000e-06 2.126354482918e-01
+ 3.480000000000e-06 2.126964275070e-01
+ 3.481000000000e-06 2.127574067222e-01
+ 3.482000000000e-06 2.128183859375e-01
+ 3.483000000000e-06 2.128793651527e-01
+ 3.484000000000e-06 2.129403443679e-01
+ 3.485000000000e-06 2.130013235831e-01
+ 3.486000000000e-06 2.130623027983e-01
+ 3.487000000000e-06 2.131232820135e-01
+ 3.488000000000e-06 2.131842612288e-01
+ 3.489000000000e-06 2.132452404440e-01
+ 3.490000000000e-06 2.133062196592e-01
+ 3.491000000000e-06 2.133671988744e-01
+ 3.492000000000e-06 2.134281780896e-01
+ 3.493000000000e-06 2.134891573048e-01
+ 3.494000000000e-06 2.135501365201e-01
+ 3.495000000000e-06 2.136111157353e-01
+ 3.496000000000e-06 2.136720949505e-01
+ 3.497000000000e-06 2.137330741657e-01
+ 3.498000000000e-06 2.137940533809e-01
+ 3.499000000000e-06 2.138550325961e-01
+ 3.500000000000e-06 2.139160118114e-01
+ 3.501000000000e-06 2.139769910266e-01
+ 3.502000000000e-06 2.140379702418e-01
+ 3.503000000000e-06 2.140989494570e-01
+ 3.504000000000e-06 2.141599286722e-01
+ 3.505000000000e-06 2.142209078874e-01
+ 3.506000000000e-06 2.142818871027e-01
+ 3.507000000000e-06 2.143428663179e-01
+ 3.508000000000e-06 2.144038455331e-01
+ 3.509000000000e-06 2.144648247483e-01
+ 3.510000000000e-06 2.145258039635e-01
+ 3.511000000000e-06 2.145867831787e-01
+ 3.512000000000e-06 2.146477623940e-01
+ 3.513000000000e-06 2.147087416092e-01
+ 3.514000000000e-06 2.147697208244e-01
+ 3.515000000000e-06 2.148307000396e-01
+ 3.516000000000e-06 2.148916792548e-01
+ 3.517000000000e-06 2.149526584700e-01
+ 3.518000000000e-06 2.150136376853e-01
+ 3.519000000000e-06 2.150746169005e-01
+ 3.520000000000e-06 2.151355961157e-01
+ 3.521000000000e-06 2.151965753309e-01
+ 3.522000000000e-06 2.152575545461e-01
+ 3.523000000000e-06 2.153185337613e-01
+ 3.524000000000e-06 2.153795129766e-01
+ 3.525000000000e-06 2.154404921918e-01
+ 3.526000000000e-06 2.155014714070e-01
+ 3.527000000000e-06 2.155624506222e-01
+ 3.528000000000e-06 2.156234298374e-01
+ 3.529000000000e-06 2.156844090526e-01
+ 3.530000000000e-06 2.157453882678e-01
+ 3.531000000000e-06 2.158063674831e-01
+ 3.532000000000e-06 2.158673466983e-01
+ 3.533000000000e-06 2.159283259135e-01
+ 3.534000000000e-06 2.159893051287e-01
+ 3.535000000000e-06 2.160502843439e-01
+ 3.536000000000e-06 2.161112635591e-01
+ 3.537000000000e-06 2.161722427744e-01
+ 3.538000000000e-06 2.162332219896e-01
+ 3.539000000000e-06 2.162942012048e-01
+ 3.540000000000e-06 2.163551804200e-01
+ 3.541000000000e-06 2.164161596352e-01
+ 3.542000000000e-06 2.164771388504e-01
+ 3.543000000000e-06 2.165381180657e-01
+ 3.544000000000e-06 2.165990972809e-01
+ 3.545000000000e-06 2.166600764961e-01
+ 3.546000000000e-06 2.167210557113e-01
+ 3.547000000000e-06 2.167820349265e-01
+ 3.548000000000e-06 2.168430141417e-01
+ 3.549000000000e-06 2.169039933570e-01
+ 3.550000000000e-06 2.169649725722e-01
+ 3.551000000000e-06 2.170259517874e-01
+ 3.552000000000e-06 2.170869310026e-01
+ 3.553000000000e-06 2.171479102178e-01
+ 3.554000000000e-06 2.172088894330e-01
+ 3.555000000000e-06 2.172698686483e-01
+ 3.556000000000e-06 2.173308478635e-01
+ 3.557000000000e-06 2.173918270787e-01
+ 3.558000000000e-06 2.174528062939e-01
+ 3.559000000000e-06 2.175137855091e-01
+ 3.560000000000e-06 2.175747647243e-01
+ 3.561000000000e-06 2.176357439396e-01
+ 3.562000000000e-06 2.176967231548e-01
+ 3.563000000000e-06 2.177577023700e-01
+ 3.564000000000e-06 2.178186815852e-01
+ 3.565000000000e-06 2.178796608004e-01
+ 3.566000000000e-06 2.179406400156e-01
+ 3.567000000000e-06 2.180016192309e-01
+ 3.568000000000e-06 2.180625984461e-01
+ 3.569000000000e-06 2.181235776613e-01
+ 3.570000000000e-06 2.181845568765e-01
+ 3.571000000000e-06 2.182455360917e-01
+ 3.572000000000e-06 2.183065153069e-01
+ 3.573000000000e-06 2.183674945222e-01
+ 3.574000000000e-06 2.184284737374e-01
+ 3.575000000000e-06 2.184894529526e-01
+ 3.576000000000e-06 2.185504321678e-01
+ 3.577000000000e-06 2.186114113830e-01
+ 3.578000000000e-06 2.186723905982e-01
+ 3.579000000000e-06 2.187333698135e-01
+ 3.580000000000e-06 2.187943490287e-01
+ 3.581000000000e-06 2.188553282439e-01
+ 3.582000000000e-06 2.189163074591e-01
+ 3.583000000000e-06 2.189772866743e-01
+ 3.584000000000e-06 2.190382658895e-01
+ 3.585000000000e-06 2.190992451048e-01
+ 3.586000000000e-06 2.191602243200e-01
+ 3.587000000000e-06 2.192212035352e-01
+ 3.588000000000e-06 2.192821827504e-01
+ 3.589000000000e-06 2.193431619656e-01
+ 3.590000000000e-06 2.194041411808e-01
+ 3.591000000000e-06 2.194651203961e-01
+ 3.592000000000e-06 2.195260996113e-01
+ 3.593000000000e-06 2.195870788265e-01
+ 3.594000000000e-06 2.196480580417e-01
+ 3.595000000000e-06 2.197090372569e-01
+ 3.596000000000e-06 2.197700164721e-01
+ 3.597000000000e-06 2.198309956874e-01
+ 3.598000000000e-06 2.198919749026e-01
+ 3.599000000000e-06 2.199529541178e-01
+ 3.600000000000e-06 2.200139333330e-01
+ 3.601000000000e-06 2.200749125482e-01
+ 3.602000000000e-06 2.201358917634e-01
+ 3.603000000000e-06 2.201968709787e-01
+ 3.604000000000e-06 2.202578501939e-01
+ 3.605000000000e-06 2.203188294091e-01
+ 3.606000000000e-06 2.203798086243e-01
+ 3.607000000000e-06 2.204407878395e-01
+ 3.608000000000e-06 2.205017670547e-01
+ 3.609000000000e-06 2.205627462700e-01
+ 3.610000000000e-06 2.206237254852e-01
+ 3.611000000000e-06 2.206847047004e-01
+ 3.612000000000e-06 2.207456839156e-01
+ 3.613000000000e-06 2.208066631308e-01
+ 3.614000000000e-06 2.208676423460e-01
+ 3.615000000000e-06 2.209286215613e-01
+ 3.616000000000e-06 2.209896007765e-01
+ 3.617000000000e-06 2.210505799917e-01
+ 3.618000000000e-06 2.211115592069e-01
+ 3.619000000000e-06 2.211725384221e-01
+ 3.620000000000e-06 2.212335176373e-01
+ 3.621000000000e-06 2.212944968526e-01
+ 3.622000000000e-06 2.213554760678e-01
+ 3.623000000000e-06 2.214164552830e-01
+ 3.624000000000e-06 2.214774344982e-01
+ 3.625000000000e-06 2.215384137134e-01
+ 3.626000000000e-06 2.215993929286e-01
+ 3.627000000000e-06 2.216603721439e-01
+ 3.628000000000e-06 2.217213513591e-01
+ 3.629000000000e-06 2.217823305743e-01
+ 3.630000000000e-06 2.218433097895e-01
+ 3.631000000000e-06 2.219042890047e-01
+ 3.632000000000e-06 2.219652682199e-01
+ 3.633000000000e-06 2.220262474352e-01
+ 3.634000000000e-06 2.220872266504e-01
+ 3.635000000000e-06 2.221482058656e-01
+ 3.636000000000e-06 2.222091850808e-01
+ 3.637000000000e-06 2.222701642960e-01
+ 3.638000000000e-06 2.223311435112e-01
+ 3.639000000000e-06 2.223921227265e-01
+ 3.640000000000e-06 2.224531019417e-01
+ 3.641000000000e-06 2.225140811569e-01
+ 3.642000000000e-06 2.225750603721e-01
+ 3.643000000000e-06 2.226360395873e-01
+ 3.644000000000e-06 2.226970188025e-01
+ 3.645000000000e-06 2.227579980178e-01
+ 3.646000000000e-06 2.228189772330e-01
+ 3.647000000000e-06 2.228799564482e-01
+ 3.648000000000e-06 2.229409356634e-01
+ 3.649000000000e-06 2.230019148786e-01
+ 3.650000000000e-06 2.230628940938e-01
+ 3.651000000000e-06 2.231238733091e-01
+ 3.652000000000e-06 2.231848525243e-01
+ 3.653000000000e-06 2.232458317395e-01
+ 3.654000000000e-06 2.233068109547e-01
+ 3.655000000000e-06 2.233677901699e-01
+ 3.656000000000e-06 2.234287693851e-01
+ 3.657000000000e-06 2.234897486004e-01
+ 3.658000000000e-06 2.235507278156e-01
+ 3.659000000000e-06 2.236117070308e-01
+ 3.660000000000e-06 2.236726862460e-01
+ 3.661000000000e-06 2.237336654612e-01
+ 3.662000000000e-06 2.237946446764e-01
+ 3.663000000000e-06 2.238556238917e-01
+ 3.664000000000e-06 2.239166031069e-01
+ 3.665000000000e-06 2.239775823221e-01
+ 3.666000000000e-06 2.240385615373e-01
+ 3.667000000000e-06 2.240995407525e-01
+ 3.668000000000e-06 2.241605199677e-01
+ 3.669000000000e-06 2.242214991830e-01
+ 3.670000000000e-06 2.242824783982e-01
+ 3.671000000000e-06 2.243434576134e-01
+ 3.672000000000e-06 2.244044368286e-01
+ 3.673000000000e-06 2.244654160438e-01
+ 3.674000000000e-06 2.245263952590e-01
+ 3.675000000000e-06 2.245873744743e-01
+ 3.676000000000e-06 2.246483536895e-01
+ 3.677000000000e-06 2.247093329047e-01
+ 3.678000000000e-06 2.247703121199e-01
+ 3.679000000000e-06 2.248312913351e-01
+ 3.680000000000e-06 2.248922705503e-01
+ 3.681000000000e-06 2.249532497656e-01
+ 3.682000000000e-06 2.250142289808e-01
+ 3.683000000000e-06 2.250752081960e-01
+ 3.684000000000e-06 2.251361874112e-01
+ 3.685000000000e-06 2.251971666264e-01
+ 3.686000000000e-06 2.252581458416e-01
+ 3.687000000000e-06 2.253191250569e-01
+ 3.688000000000e-06 2.253801042721e-01
+ 3.689000000000e-06 2.254410834873e-01
+ 3.690000000000e-06 2.255020627025e-01
+ 3.691000000000e-06 2.255630419177e-01
+ 3.692000000000e-06 2.256240211329e-01
+ 3.693000000000e-06 2.256850003482e-01
+ 3.694000000000e-06 2.257459795634e-01
+ 3.695000000000e-06 2.258069587786e-01
+ 3.696000000000e-06 2.258679379938e-01
+ 3.697000000000e-06 2.259289172090e-01
+ 3.698000000000e-06 2.259898964242e-01
+ 3.699000000000e-06 2.260508756395e-01
+ 3.700000000000e-06 2.261118548547e-01
+ 3.701000000000e-06 2.261728340699e-01
+ 3.702000000000e-06 2.262338132851e-01
+ 3.703000000000e-06 2.262947925003e-01
+ 3.704000000000e-06 2.263557717155e-01
+ 3.705000000000e-06 2.264167509308e-01
+ 3.706000000000e-06 2.264777301460e-01
+ 3.707000000000e-06 2.265387093612e-01
+ 3.708000000000e-06 2.265996885764e-01
+ 3.709000000000e-06 2.266606677916e-01
+ 3.710000000000e-06 2.267216470068e-01
+ 3.711000000000e-06 2.267826262221e-01
+ 3.712000000000e-06 2.268436054373e-01
+ 3.713000000000e-06 2.269045846525e-01
+ 3.714000000000e-06 2.269655638677e-01
+ 3.715000000000e-06 2.270265430829e-01
+ 3.716000000000e-06 2.270875222981e-01
+ 3.717000000000e-06 2.271485015134e-01
+ 3.718000000000e-06 2.272094807286e-01
+ 3.719000000000e-06 2.272704599438e-01
+ 3.720000000000e-06 2.273314391590e-01
+ 3.721000000000e-06 2.273924183742e-01
+ 3.722000000000e-06 2.274533975894e-01
+ 3.723000000000e-06 2.275143768047e-01
+ 3.724000000000e-06 2.275753560199e-01
+ 3.725000000000e-06 2.276363352351e-01
+ 3.726000000000e-06 2.276973144503e-01
+ 3.727000000000e-06 2.277582936655e-01
+ 3.728000000000e-06 2.278192728807e-01
+ 3.729000000000e-06 2.278802520960e-01
+ 3.730000000000e-06 2.279412313112e-01
+ 3.731000000000e-06 2.280022105264e-01
+ 3.732000000000e-06 2.280631897416e-01
+ 3.733000000000e-06 2.281241689568e-01
+ 3.734000000000e-06 2.281851481720e-01
+ 3.735000000000e-06 2.282461273873e-01
+ 3.736000000000e-06 2.283071066025e-01
+ 3.737000000000e-06 2.283680858177e-01
+ 3.738000000000e-06 2.284290650329e-01
+ 3.739000000000e-06 2.284900442481e-01
+ 3.740000000000e-06 2.285510234633e-01
+ 3.741000000000e-06 2.286120026786e-01
+ 3.742000000000e-06 2.286729818938e-01
+ 3.743000000000e-06 2.287339611090e-01
+ 3.744000000000e-06 2.287949403242e-01
+ 3.745000000000e-06 2.288559195394e-01
+ 3.746000000000e-06 2.289168987546e-01
+ 3.747000000000e-06 2.289778779699e-01
+ 3.748000000000e-06 2.290388571851e-01
+ 3.749000000000e-06 2.290998364003e-01
+ 3.750000000000e-06 2.291608156155e-01
+ 3.751000000000e-06 2.292217948307e-01
+ 3.752000000000e-06 2.292827740459e-01
+ 3.753000000000e-06 2.293437532611e-01
+ 3.754000000000e-06 2.294047324764e-01
+ 3.755000000000e-06 2.294657116916e-01
+ 3.756000000000e-06 2.295266909068e-01
+ 3.757000000000e-06 2.295876701220e-01
+ 3.758000000000e-06 2.296486493372e-01
+ 3.759000000000e-06 2.297096285524e-01
+ 3.760000000000e-06 2.297706077677e-01
+ 3.761000000000e-06 2.298315869829e-01
+ 3.762000000000e-06 2.298925661981e-01
+ 3.763000000000e-06 2.299535454133e-01
+ 3.764000000000e-06 2.300145246285e-01
+ 3.765000000000e-06 2.300755038437e-01
+ 3.766000000000e-06 2.301364830590e-01
+ 3.767000000000e-06 2.301974622742e-01
+ 3.768000000000e-06 2.302584414894e-01
+ 3.769000000000e-06 2.303194207046e-01
+ 3.770000000000e-06 2.303803999198e-01
+ 3.771000000000e-06 2.304413791350e-01
+ 3.772000000000e-06 2.305023583503e-01
+ 3.773000000000e-06 2.305633375655e-01
+ 3.774000000000e-06 2.306243167807e-01
+ 3.775000000000e-06 2.306852959959e-01
+ 3.776000000000e-06 2.307462752111e-01
+ 3.777000000000e-06 2.308072544263e-01
+ 3.778000000000e-06 2.308682336416e-01
+ 3.779000000000e-06 2.309292128568e-01
+ 3.780000000000e-06 2.309901920720e-01
+ 3.781000000000e-06 2.310511712872e-01
+ 3.782000000000e-06 2.311121505024e-01
+ 3.783000000000e-06 2.311731297176e-01
+ 3.784000000000e-06 2.312341089329e-01
+ 3.785000000000e-06 2.312950881481e-01
+ 3.786000000000e-06 2.313560673633e-01
+ 3.787000000000e-06 2.314170465785e-01
+ 3.788000000000e-06 2.314780257937e-01
+ 3.789000000000e-06 2.315390050089e-01
+ 3.790000000000e-06 2.315999842242e-01
+ 3.791000000000e-06 2.316609634394e-01
+ 3.792000000000e-06 2.317219426546e-01
+ 3.793000000000e-06 2.317829218698e-01
+ 3.794000000000e-06 2.318439010850e-01
+ 3.795000000000e-06 2.319048803002e-01
+ 3.796000000000e-06 2.319658595155e-01
+ 3.797000000000e-06 2.320268387307e-01
+ 3.798000000000e-06 2.320878179459e-01
+ 3.799000000000e-06 2.321487971611e-01
+ 3.800000000000e-06 2.322097763763e-01
+ 3.801000000000e-06 2.322707555915e-01
+ 3.802000000000e-06 2.323317348068e-01
+ 3.803000000000e-06 2.323927140220e-01
+ 3.804000000000e-06 2.324536932372e-01
+ 3.805000000000e-06 2.325146724524e-01
+ 3.806000000000e-06 2.325756516676e-01
+ 3.807000000000e-06 2.326366308828e-01
+ 3.808000000000e-06 2.326976100981e-01
+ 3.809000000000e-06 2.327585893133e-01
+ 3.810000000000e-06 2.328195685285e-01
+ 3.811000000000e-06 2.328805477437e-01
+ 3.812000000000e-06 2.329415269589e-01
+ 3.813000000000e-06 2.330025061741e-01
+ 3.814000000000e-06 2.330634853894e-01
+ 3.815000000000e-06 2.331244646046e-01
+ 3.816000000000e-06 2.331854438198e-01
+ 3.817000000000e-06 2.332464230350e-01
+ 3.818000000000e-06 2.333074022502e-01
+ 3.819000000000e-06 2.333683814654e-01
+ 3.820000000000e-06 2.334293606807e-01
+ 3.821000000000e-06 2.334903398959e-01
+ 3.822000000000e-06 2.335513191111e-01
+ 3.823000000000e-06 2.336122983263e-01
+ 3.824000000000e-06 2.336732775415e-01
+ 3.825000000000e-06 2.337342567567e-01
+ 3.826000000000e-06 2.337952359720e-01
+ 3.827000000000e-06 2.338562151872e-01
+ 3.828000000000e-06 2.339171944024e-01
+ 3.829000000000e-06 2.339781736176e-01
+ 3.830000000000e-06 2.340391528328e-01
+ 3.831000000000e-06 2.341001320480e-01
+ 3.832000000000e-06 2.341611112633e-01
+ 3.833000000000e-06 2.342220904785e-01
+ 3.834000000000e-06 2.342830696937e-01
+ 3.835000000000e-06 2.343440489089e-01
+ 3.836000000000e-06 2.344050281241e-01
+ 3.837000000000e-06 2.344660073393e-01
+ 3.838000000000e-06 2.345269865546e-01
+ 3.839000000000e-06 2.345879657698e-01
+ 3.840000000000e-06 2.346489449850e-01
+ 3.841000000000e-06 2.347099242002e-01
+ 3.842000000000e-06 2.347709034154e-01
+ 3.843000000000e-06 2.348318826306e-01
+ 3.844000000000e-06 2.348928618459e-01
+ 3.845000000000e-06 2.349538410611e-01
+ 3.846000000000e-06 2.350148202763e-01
+ 3.847000000000e-06 2.350757994915e-01
+ 3.848000000000e-06 2.351367787067e-01
+ 3.849000000000e-06 2.351977579219e-01
+ 3.850000000000e-06 2.352587371372e-01
+ 3.851000000000e-06 2.353197163524e-01
+ 3.852000000000e-06 2.353806955676e-01
+ 3.853000000000e-06 2.354416747828e-01
+ 3.854000000000e-06 2.355026539980e-01
+ 3.855000000000e-06 2.355636332132e-01
+ 3.856000000000e-06 2.356246124285e-01
+ 3.857000000000e-06 2.356855916437e-01
+ 3.858000000000e-06 2.357465708589e-01
+ 3.859000000000e-06 2.358075500741e-01
+ 3.860000000000e-06 2.358685292893e-01
+ 3.861000000000e-06 2.359295085045e-01
+ 3.862000000000e-06 2.359904877198e-01
+ 3.863000000000e-06 2.360514669350e-01
+ 3.864000000000e-06 2.361124461502e-01
+ 3.865000000000e-06 2.361734253654e-01
+ 3.866000000000e-06 2.362344045806e-01
+ 3.867000000000e-06 2.362953837958e-01
+ 3.868000000000e-06 2.363563630111e-01
+ 3.869000000000e-06 2.364173422263e-01
+ 3.870000000000e-06 2.364783214415e-01
+ 3.871000000000e-06 2.365393006567e-01
+ 3.872000000000e-06 2.366002798719e-01
+ 3.873000000000e-06 2.366612590871e-01
+ 3.874000000000e-06 2.367222383024e-01
+ 3.875000000000e-06 2.367832175176e-01
+ 3.876000000000e-06 2.368441967328e-01
+ 3.877000000000e-06 2.369051759480e-01
+ 3.878000000000e-06 2.369661551632e-01
+ 3.879000000000e-06 2.370271343784e-01
+ 3.880000000000e-06 2.370881135937e-01
+ 3.881000000000e-06 2.371490928089e-01
+ 3.882000000000e-06 2.372100720241e-01
+ 3.883000000000e-06 2.372710512393e-01
+ 3.884000000000e-06 2.373320304545e-01
+ 3.885000000000e-06 2.373930096697e-01
+ 3.886000000000e-06 2.374539888850e-01
+ 3.887000000000e-06 2.375149681002e-01
+ 3.888000000000e-06 2.375759473154e-01
+ 3.889000000000e-06 2.376369265306e-01
+ 3.890000000000e-06 2.376979057458e-01
+ 3.891000000000e-06 2.377588849610e-01
+ 3.892000000000e-06 2.378198641763e-01
+ 3.893000000000e-06 2.378808433915e-01
+ 3.894000000000e-06 2.379418226067e-01
+ 3.895000000000e-06 2.380028018219e-01
+ 3.896000000000e-06 2.380637810371e-01
+ 3.897000000000e-06 2.381247602523e-01
+ 3.898000000000e-06 2.381857394676e-01
+ 3.899000000000e-06 2.382467186828e-01
+ 3.900000000000e-06 2.383076978980e-01
+ 3.901000000000e-06 2.383686771132e-01
+ 3.902000000000e-06 2.384296563284e-01
+ 3.903000000000e-06 2.384906355436e-01
+ 3.904000000000e-06 2.385516147589e-01
+ 3.905000000000e-06 2.386125939741e-01
+ 3.906000000000e-06 2.386735731893e-01
+ 3.907000000000e-06 2.387345524045e-01
+ 3.908000000000e-06 2.387955316197e-01
+ 3.909000000000e-06 2.388565108349e-01
+ 3.910000000000e-06 2.389174900502e-01
+ 3.911000000000e-06 2.389784692654e-01
+ 3.912000000000e-06 2.390394484806e-01
+ 3.913000000000e-06 2.391004276958e-01
+ 3.914000000000e-06 2.391614069110e-01
+ 3.915000000000e-06 2.392223861262e-01
+ 3.916000000000e-06 2.392833653415e-01
+ 3.917000000000e-06 2.393443445567e-01
+ 3.918000000000e-06 2.394053237719e-01
+ 3.919000000000e-06 2.394663029871e-01
+ 3.920000000000e-06 2.395272822023e-01
+ 3.921000000000e-06 2.395882614175e-01
+ 3.922000000000e-06 2.396492406328e-01
+ 3.923000000000e-06 2.397102198480e-01
+ 3.924000000000e-06 2.397711990632e-01
+ 3.925000000000e-06 2.398321782784e-01
+ 3.926000000000e-06 2.398931574936e-01
+ 3.927000000000e-06 2.399541367088e-01
+ 3.928000000000e-06 2.400151159241e-01
+ 3.929000000000e-06 2.400760951393e-01
+ 3.930000000000e-06 2.401370743545e-01
+ 3.931000000000e-06 2.401980535697e-01
+ 3.932000000000e-06 2.402590327849e-01
+ 3.933000000000e-06 2.403200120001e-01
+ 3.934000000000e-06 2.403809912154e-01
+ 3.935000000000e-06 2.404419704306e-01
+ 3.936000000000e-06 2.405029496458e-01
+ 3.937000000000e-06 2.405639288610e-01
+ 3.938000000000e-06 2.406249080762e-01
+ 3.939000000000e-06 2.406858872914e-01
+ 3.940000000000e-06 2.407468665067e-01
+ 3.941000000000e-06 2.408078457219e-01
+ 3.942000000000e-06 2.408688249371e-01
+ 3.943000000000e-06 2.409298041523e-01
+ 3.944000000000e-06 2.409907833675e-01
+ 3.945000000000e-06 2.410517625827e-01
+ 3.946000000000e-06 2.411127417980e-01
+ 3.947000000000e-06 2.411737210132e-01
+ 3.948000000000e-06 2.412347002284e-01
+ 3.949000000000e-06 2.412956794436e-01
+ 3.950000000000e-06 2.413566586588e-01
+ 3.951000000000e-06 2.414176378740e-01
+ 3.952000000000e-06 2.414786170893e-01
+ 3.953000000000e-06 2.415395963045e-01
+ 3.954000000000e-06 2.416005755197e-01
+ 3.955000000000e-06 2.416615547349e-01
+ 3.956000000000e-06 2.417225339501e-01
+ 3.957000000000e-06 2.417835131653e-01
+ 3.958000000000e-06 2.418444923806e-01
+ 3.959000000000e-06 2.419054715958e-01
+ 3.960000000000e-06 2.419664508110e-01
+ 3.961000000000e-06 2.420274300262e-01
+ 3.962000000000e-06 2.420884092414e-01
+ 3.963000000000e-06 2.421493884566e-01
+ 3.964000000000e-06 2.422103676719e-01
+ 3.965000000000e-06 2.422713468871e-01
+ 3.966000000000e-06 2.423323261023e-01
+ 3.967000000000e-06 2.423933053175e-01
+ 3.968000000000e-06 2.424542845327e-01
+ 3.969000000000e-06 2.425152637479e-01
+ 3.970000000000e-06 2.425762429632e-01
+ 3.971000000000e-06 2.426372221784e-01
+ 3.972000000000e-06 2.426982013936e-01
+ 3.973000000000e-06 2.427591806088e-01
+ 3.974000000000e-06 2.428201598240e-01
+ 3.975000000000e-06 2.428811390392e-01
+ 3.976000000000e-06 2.429421182545e-01
+ 3.977000000000e-06 2.430030974697e-01
+ 3.978000000000e-06 2.430640766849e-01
+ 3.979000000000e-06 2.431250559001e-01
+ 3.980000000000e-06 2.431860351153e-01
+ 3.981000000000e-06 2.432470143305e-01
+ 3.982000000000e-06 2.433079935457e-01
+ 3.983000000000e-06 2.433689727610e-01
+ 3.984000000000e-06 2.434299519762e-01
+ 3.985000000000e-06 2.434909311914e-01
+ 3.986000000000e-06 2.435519104066e-01
+ 3.987000000000e-06 2.436128896218e-01
+ 3.988000000000e-06 2.436738688370e-01
+ 3.989000000000e-06 2.437348480523e-01
+ 3.990000000000e-06 2.437958272675e-01
+ 3.991000000000e-06 2.438568064827e-01
+ 3.992000000000e-06 2.439177856979e-01
+ 3.993000000000e-06 2.439787649131e-01
+ 3.994000000000e-06 2.440397441283e-01
+ 3.995000000000e-06 2.441007233436e-01
+ 3.996000000000e-06 2.441617025588e-01
+ 3.997000000000e-06 2.442226817740e-01
+ 3.998000000000e-06 2.442836609892e-01
+ 3.999000000000e-06 2.443446402044e-01
+ 4.000000000000e-06 2.444056194196e-01
+ 4.001000000000e-06 2.444665986349e-01
+ 4.002000000000e-06 2.445275778501e-01
+ 4.003000000000e-06 2.445885570653e-01
+ 4.004000000000e-06 2.446495362805e-01
+ 4.005000000000e-06 2.447105154957e-01
+ 4.006000000000e-06 2.447714947109e-01
+ 4.007000000000e-06 2.448324739262e-01
+ 4.008000000000e-06 2.448934531414e-01
+ 4.009000000000e-06 2.449544323566e-01
+ 4.010000000000e-06 2.450154115718e-01
+ 4.011000000000e-06 2.450763907870e-01
+ 4.012000000000e-06 2.451373700022e-01
+ 4.013000000000e-06 2.451983492175e-01
+ 4.014000000000e-06 2.452593284327e-01
+ 4.015000000000e-06 2.453203076479e-01
+ 4.016000000000e-06 2.453812868631e-01
+ 4.017000000000e-06 2.454422660783e-01
+ 4.018000000000e-06 2.455032452935e-01
+ 4.019000000000e-06 2.455642245088e-01
+ 4.020000000000e-06 2.456252037240e-01
+ 4.021000000000e-06 2.456861829392e-01
+ 4.022000000000e-06 2.457471621544e-01
+ 4.023000000000e-06 2.458081413696e-01
+ 4.024000000000e-06 2.458691205848e-01
+ 4.025000000000e-06 2.459300998001e-01
+ 4.026000000000e-06 2.459910790153e-01
+ 4.027000000000e-06 2.460520582305e-01
+ 4.028000000000e-06 2.461130374457e-01
+ 4.029000000000e-06 2.461740166609e-01
+ 4.030000000000e-06 2.462349958761e-01
+ 4.031000000000e-06 2.462959750914e-01
+ 4.032000000000e-06 2.463569543066e-01
+ 4.033000000000e-06 2.464179335218e-01
+ 4.034000000000e-06 2.464789127370e-01
+ 4.035000000000e-06 2.465398919522e-01
+ 4.036000000000e-06 2.466008711674e-01
+ 4.037000000000e-06 2.466618503827e-01
+ 4.038000000000e-06 2.467228295979e-01
+ 4.039000000000e-06 2.467838088131e-01
+ 4.040000000000e-06 2.468447880283e-01
+ 4.041000000000e-06 2.469057672435e-01
+ 4.042000000000e-06 2.469667464587e-01
+ 4.043000000000e-06 2.470277256740e-01
+ 4.044000000000e-06 2.470887048892e-01
+ 4.045000000000e-06 2.471496841044e-01
+ 4.046000000000e-06 2.472106633196e-01
+ 4.047000000000e-06 2.472716425348e-01
+ 4.048000000000e-06 2.473326217500e-01
+ 4.049000000000e-06 2.473936009653e-01
+ 4.050000000000e-06 2.474545801805e-01
+ 4.051000000000e-06 2.475155593957e-01
+ 4.052000000000e-06 2.475765386109e-01
+ 4.053000000000e-06 2.476375178261e-01
+ 4.054000000000e-06 2.476984970413e-01
+ 4.055000000000e-06 2.477594762566e-01
+ 4.056000000000e-06 2.478204554718e-01
+ 4.057000000000e-06 2.478814346870e-01
+ 4.058000000000e-06 2.479424139022e-01
+ 4.059000000000e-06 2.480033931174e-01
+ 4.060000000000e-06 2.480643723326e-01
+ 4.061000000000e-06 2.481253515479e-01
+ 4.062000000000e-06 2.481863307631e-01
+ 4.063000000000e-06 2.482473099783e-01
+ 4.064000000000e-06 2.483082891935e-01
+ 4.065000000000e-06 2.483692684087e-01
+ 4.066000000000e-06 2.484302476239e-01
+ 4.067000000000e-06 2.484912268392e-01
+ 4.068000000000e-06 2.485522060544e-01
+ 4.069000000000e-06 2.486131852696e-01
+ 4.070000000000e-06 2.486741644848e-01
+ 4.071000000000e-06 2.487351437000e-01
+ 4.072000000000e-06 2.487961229152e-01
+ 4.073000000000e-06 2.488571021305e-01
+ 4.074000000000e-06 2.489180813457e-01
+ 4.075000000000e-06 2.489790605609e-01
+ 4.076000000000e-06 2.490400397761e-01
+ 4.077000000000e-06 2.491010189913e-01
+ 4.078000000000e-06 2.491619982065e-01
+ 4.079000000000e-06 2.492229774218e-01
+ 4.080000000000e-06 2.492839566370e-01
+ 4.081000000000e-06 2.493449358522e-01
+ 4.082000000000e-06 2.494059150674e-01
+ 4.083000000000e-06 2.494668942826e-01
+ 4.084000000000e-06 2.495278734978e-01
+ 4.085000000000e-06 2.495888527131e-01
+ 4.086000000000e-06 2.496498319283e-01
+ 4.087000000000e-06 2.497108111435e-01
+ 4.088000000000e-06 2.497717903587e-01
+ 4.089000000000e-06 2.498327695739e-01
+ 4.090000000000e-06 2.498937487891e-01
+ 4.091000000000e-06 2.499547280044e-01
+ 4.092000000000e-06 2.500157072196e-01
+ 4.093000000000e-06 2.500766864348e-01
+ 4.094000000000e-06 2.501376656500e-01
+ 4.095000000000e-06 2.501986448652e-01
+ 4.096000000000e-06 2.502596240804e-01
+ 4.097000000000e-06 2.503206032957e-01
+ 4.098000000000e-06 2.503815825109e-01
+ 4.099000000000e-06 2.504425617261e-01
+ 4.100000000000e-06 2.505035409413e-01
+ 4.101000000000e-06 2.505645201565e-01
+ 4.102000000000e-06 2.506254993717e-01
+ 4.103000000000e-06 2.506864785870e-01
+ 4.104000000000e-06 2.507474578022e-01
+ 4.105000000000e-06 2.508084370174e-01
+ 4.106000000000e-06 2.508694162326e-01
+ 4.107000000000e-06 2.509303954478e-01
+ 4.108000000000e-06 2.509913746630e-01
+ 4.109000000000e-06 2.510523538783e-01
+ 4.110000000000e-06 2.511133330935e-01
+ 4.111000000000e-06 2.511743123087e-01
+ 4.112000000000e-06 2.512352915239e-01
+ 4.113000000000e-06 2.512962707391e-01
+ 4.114000000000e-06 2.513572499543e-01
+ 4.115000000000e-06 2.514182291696e-01
+ 4.116000000000e-06 2.514792083848e-01
+ 4.117000000000e-06 2.515401876000e-01
+ 4.118000000000e-06 2.516011668152e-01
+ 4.119000000000e-06 2.516621460304e-01
+ 4.120000000000e-06 2.517231252456e-01
+ 4.121000000000e-06 2.517841044609e-01
+ 4.122000000000e-06 2.518450836761e-01
+ 4.123000000000e-06 2.519060628913e-01
+ 4.124000000000e-06 2.519670421065e-01
+ 4.125000000000e-06 2.520280213217e-01
+ 4.126000000000e-06 2.520890005369e-01
+ 4.127000000000e-06 2.521499797522e-01
+ 4.128000000000e-06 2.522109589674e-01
+ 4.129000000000e-06 2.522719381826e-01
+ 4.130000000000e-06 2.523329173978e-01
+ 4.131000000000e-06 2.523938966130e-01
+ 4.132000000000e-06 2.524548758282e-01
+ 4.133000000000e-06 2.525158550435e-01
+ 4.134000000000e-06 2.525768342587e-01
+ 4.135000000000e-06 2.526378134739e-01
+ 4.136000000000e-06 2.526987926891e-01
+ 4.137000000000e-06 2.527597719043e-01
+ 4.138000000000e-06 2.528207511195e-01
+ 4.139000000000e-06 2.528817303348e-01
+ 4.140000000000e-06 2.529427095500e-01
+ 4.141000000000e-06 2.530036887652e-01
+ 4.142000000000e-06 2.530646679804e-01
+ 4.143000000000e-06 2.531256471956e-01
+ 4.144000000000e-06 2.531866264108e-01
+ 4.145000000000e-06 2.532476056261e-01
+ 4.146000000000e-06 2.533085848413e-01
+ 4.147000000000e-06 2.533695640565e-01
+ 4.148000000000e-06 2.534305432717e-01
+ 4.149000000000e-06 2.534915224869e-01
+ 4.150000000000e-06 2.535525017021e-01
+ 4.151000000000e-06 2.536134809174e-01
+ 4.152000000000e-06 2.536744601326e-01
+ 4.153000000000e-06 2.537354393478e-01
+ 4.154000000000e-06 2.537964185630e-01
+ 4.155000000000e-06 2.538573977782e-01
+ 4.156000000000e-06 2.539183769934e-01
+ 4.157000000000e-06 2.539793562087e-01
+ 4.158000000000e-06 2.540403354239e-01
+ 4.159000000000e-06 2.541013146391e-01
+ 4.160000000000e-06 2.541622938543e-01
+ 4.161000000000e-06 2.542232730695e-01
+ 4.162000000000e-06 2.542842522847e-01
+ 4.163000000000e-06 2.543452315000e-01
+ 4.164000000000e-06 2.544062107152e-01
+ 4.165000000000e-06 2.544671899304e-01
+ 4.166000000000e-06 2.545281691456e-01
+ 4.167000000000e-06 2.545891483608e-01
+ 4.168000000000e-06 2.546501275760e-01
+ 4.169000000000e-06 2.547111067913e-01
+ 4.170000000000e-06 2.547720860065e-01
+ 4.171000000000e-06 2.548330652217e-01
+ 4.172000000000e-06 2.548940444369e-01
+ 4.173000000000e-06 2.549550236521e-01
+ 4.174000000000e-06 2.550160028673e-01
+ 4.175000000000e-06 2.550769820826e-01
+ 4.176000000000e-06 2.551379612978e-01
+ 4.177000000000e-06 2.551989405130e-01
+ 4.178000000000e-06 2.552599197282e-01
+ 4.179000000000e-06 2.553208989434e-01
+ 4.180000000000e-06 2.553818781586e-01
+ 4.181000000000e-06 2.554428573739e-01
+ 4.182000000000e-06 2.555038365891e-01
+ 4.183000000000e-06 2.555648158043e-01
+ 4.184000000000e-06 2.556257950195e-01
+ 4.185000000000e-06 2.556867742347e-01
+ 4.186000000000e-06 2.557477534499e-01
+ 4.187000000000e-06 2.558087326652e-01
+ 4.188000000000e-06 2.558697118804e-01
+ 4.189000000000e-06 2.559306910956e-01
+ 4.190000000000e-06 2.559916703108e-01
+ 4.191000000000e-06 2.560526495260e-01
+ 4.192000000000e-06 2.561136287412e-01
+ 4.193000000000e-06 2.561746079565e-01
+ 4.194000000000e-06 2.562355871717e-01
+ 4.195000000000e-06 2.562965663869e-01
+ 4.196000000000e-06 2.563575456021e-01
+ 4.197000000000e-06 2.564185248173e-01
+ 4.198000000000e-06 2.564795040325e-01
+ 4.199000000000e-06 2.565404832478e-01
+ 4.200000000000e-06 2.566014624630e-01
+ 4.201000000000e-06 2.566624416782e-01
+ 4.202000000000e-06 2.567234208934e-01
+ 4.203000000000e-06 2.567844001086e-01
+ 4.204000000000e-06 2.568453793238e-01
+ 4.205000000000e-06 2.569063585391e-01
+ 4.206000000000e-06 2.569673377543e-01
+ 4.207000000000e-06 2.570283169695e-01
+ 4.208000000000e-06 2.570892961847e-01
+ 4.209000000000e-06 2.571502753999e-01
+ 4.210000000000e-06 2.572112546151e-01
+ 4.211000000000e-06 2.572722338303e-01
+ 4.212000000000e-06 2.573332130456e-01
+ 4.213000000000e-06 2.573941922608e-01
+ 4.214000000000e-06 2.574551714760e-01
+ 4.215000000000e-06 2.575161506912e-01
+ 4.216000000000e-06 2.575771299064e-01
+ 4.217000000000e-06 2.576381091216e-01
+ 4.218000000000e-06 2.576990883369e-01
+ 4.219000000000e-06 2.577600675521e-01
+ 4.220000000000e-06 2.578210467673e-01
+ 4.221000000000e-06 2.578820259825e-01
+ 4.222000000000e-06 2.579430051977e-01
+ 4.223000000000e-06 2.580039844129e-01
+ 4.224000000000e-06 2.580649636282e-01
+ 4.225000000000e-06 2.581259428434e-01
+ 4.226000000000e-06 2.581869220586e-01
+ 4.227000000000e-06 2.582479012738e-01
+ 4.228000000000e-06 2.583088804890e-01
+ 4.229000000000e-06 2.583698597042e-01
+ 4.230000000000e-06 2.584308389195e-01
+ 4.231000000000e-06 2.584918181347e-01
+ 4.232000000000e-06 2.585527973499e-01
+ 4.233000000000e-06 2.586137765651e-01
+ 4.234000000000e-06 2.586747557803e-01
+ 4.235000000000e-06 2.587357349955e-01
+ 4.236000000000e-06 2.587967142108e-01
+ 4.237000000000e-06 2.588576934260e-01
+ 4.238000000000e-06 2.589186726412e-01
+ 4.239000000000e-06 2.589796518564e-01
+ 4.240000000000e-06 2.590406310716e-01
+ 4.241000000000e-06 2.591016102868e-01
+ 4.242000000000e-06 2.591625895021e-01
+ 4.243000000000e-06 2.592235687173e-01
+ 4.244000000000e-06 2.592845479325e-01
+ 4.245000000000e-06 2.593455271477e-01
+ 4.246000000000e-06 2.594065063629e-01
+ 4.247000000000e-06 2.594674855781e-01
+ 4.248000000000e-06 2.595284647934e-01
+ 4.249000000000e-06 2.595894440086e-01
+ 4.250000000000e-06 2.596504232238e-01
+ 4.251000000000e-06 2.597114024390e-01
+ 4.252000000000e-06 2.597723816542e-01
+ 4.253000000000e-06 2.598333608694e-01
+ 4.254000000000e-06 2.598943400847e-01
+ 4.255000000000e-06 2.599553192999e-01
+ 4.256000000000e-06 2.600162985151e-01
+ 4.257000000000e-06 2.600772777303e-01
+ 4.258000000000e-06 2.601382569455e-01
+ 4.259000000000e-06 2.601992361607e-01
+ 4.260000000000e-06 2.602602153760e-01
+ 4.261000000000e-06 2.603211945912e-01
+ 4.262000000000e-06 2.603821738064e-01
+ 4.263000000000e-06 2.604431530216e-01
+ 4.264000000000e-06 2.605041322368e-01
+ 4.265000000000e-06 2.605651114520e-01
+ 4.266000000000e-06 2.606260906673e-01
+ 4.267000000000e-06 2.606870698825e-01
+ 4.268000000000e-06 2.607480490977e-01
+ 4.269000000000e-06 2.608090283129e-01
+ 4.270000000000e-06 2.608700075281e-01
+ 4.271000000000e-06 2.609309867433e-01
+ 4.272000000000e-06 2.609919659586e-01
+ 4.273000000000e-06 2.610529451738e-01
+ 4.274000000000e-06 2.611139243890e-01
+ 4.275000000000e-06 2.611749036042e-01
+ 4.276000000000e-06 2.612358828194e-01
+ 4.277000000000e-06 2.612968620346e-01
+ 4.278000000000e-06 2.613578412499e-01
+ 4.279000000000e-06 2.614188204651e-01
+ 4.280000000000e-06 2.614797996803e-01
+ 4.281000000000e-06 2.615407788955e-01
+ 4.282000000000e-06 2.616017581107e-01
+ 4.283000000000e-06 2.616627373259e-01
+ 4.284000000000e-06 2.617237165412e-01
+ 4.285000000000e-06 2.617846957564e-01
+ 4.286000000000e-06 2.618456749716e-01
+ 4.287000000000e-06 2.619066541868e-01
+ 4.288000000000e-06 2.619676334020e-01
+ 4.289000000000e-06 2.620286126172e-01
+ 4.290000000000e-06 2.620895918325e-01
+ 4.291000000000e-06 2.621505710477e-01
+ 4.292000000000e-06 2.622115502629e-01
+ 4.293000000000e-06 2.622725294781e-01
+ 4.294000000000e-06 2.623335086933e-01
+ 4.295000000000e-06 2.623944879085e-01
+ 4.296000000000e-06 2.624554671238e-01
+ 4.297000000000e-06 2.625164463390e-01
+ 4.298000000000e-06 2.625774255542e-01
+ 4.299000000000e-06 2.626384047694e-01
+ 4.300000000000e-06 2.626993839846e-01
+ 4.301000000000e-06 2.627603631998e-01
+ 4.302000000000e-06 2.628213424151e-01
+ 4.303000000000e-06 2.628823216303e-01
+ 4.304000000000e-06 2.629433008455e-01
+ 4.305000000000e-06 2.630042800607e-01
+ 4.306000000000e-06 2.630652592759e-01
+ 4.307000000000e-06 2.631262384911e-01
+ 4.308000000000e-06 2.631872177064e-01
+ 4.309000000000e-06 2.632481969216e-01
+ 4.310000000000e-06 2.633091761368e-01
+ 4.311000000000e-06 2.633701553520e-01
+ 4.312000000000e-06 2.634311345672e-01
+ 4.313000000000e-06 2.634921137824e-01
+ 4.314000000000e-06 2.635530929977e-01
+ 4.315000000000e-06 2.636140722129e-01
+ 4.316000000000e-06 2.636750514281e-01
+ 4.317000000000e-06 2.637360306433e-01
+ 4.318000000000e-06 2.637970098585e-01
+ 4.319000000000e-06 2.638579890737e-01
+ 4.320000000000e-06 2.639189682890e-01
+ 4.321000000000e-06 2.639799475042e-01
+ 4.322000000000e-06 2.640409267194e-01
+ 4.323000000000e-06 2.641019059346e-01
+ 4.324000000000e-06 2.641628851498e-01
+ 4.325000000000e-06 2.642238643650e-01
+ 4.326000000000e-06 2.642848435803e-01
+ 4.327000000000e-06 2.643458227955e-01
+ 4.328000000000e-06 2.644068020107e-01
+ 4.329000000000e-06 2.644677812259e-01
+ 4.330000000000e-06 2.645287604411e-01
+ 4.331000000000e-06 2.645897396563e-01
+ 4.332000000000e-06 2.646507188716e-01
+ 4.333000000000e-06 2.647116980868e-01
+ 4.334000000000e-06 2.647726773020e-01
+ 4.335000000000e-06 2.648336565172e-01
+ 4.336000000000e-06 2.648946357324e-01
+ 4.337000000000e-06 2.649556149476e-01
+ 4.338000000000e-06 2.650165941629e-01
+ 4.339000000000e-06 2.650775733781e-01
+ 4.340000000000e-06 2.651385525933e-01
+ 4.341000000000e-06 2.651995318085e-01
+ 4.342000000000e-06 2.652605110237e-01
+ 4.343000000000e-06 2.653214902389e-01
+ 4.344000000000e-06 2.653824694542e-01
+ 4.345000000000e-06 2.654434486694e-01
+ 4.346000000000e-06 2.655044278846e-01
+ 4.347000000000e-06 2.655654070998e-01
+ 4.348000000000e-06 2.656263863150e-01
+ 4.349000000000e-06 2.656873655302e-01
+ 4.350000000000e-06 2.657483447455e-01
+ 4.351000000000e-06 2.658093239607e-01
+ 4.352000000000e-06 2.658703031759e-01
+ 4.353000000000e-06 2.659312823911e-01
+ 4.354000000000e-06 2.659922616063e-01
+ 4.355000000000e-06 2.660532408215e-01
+ 4.356000000000e-06 2.661142200368e-01
+ 4.357000000000e-06 2.661751992520e-01
+ 4.358000000000e-06 2.662361784672e-01
+ 4.359000000000e-06 2.662971576824e-01
+ 4.360000000000e-06 2.663581368976e-01
+ 4.361000000000e-06 2.664191161128e-01
+ 4.362000000000e-06 2.664800953281e-01
+ 4.363000000000e-06 2.665410745433e-01
+ 4.364000000000e-06 2.666020537585e-01
+ 4.365000000000e-06 2.666630329737e-01
+ 4.366000000000e-06 2.667240121889e-01
+ 4.367000000000e-06 2.667849914041e-01
+ 4.368000000000e-06 2.668459706194e-01
+ 4.369000000000e-06 2.669069498346e-01
+ 4.370000000000e-06 2.669679290498e-01
+ 4.371000000000e-06 2.670289082650e-01
+ 4.372000000000e-06 2.670898874802e-01
+ 4.373000000000e-06 2.671508666954e-01
+ 4.374000000000e-06 2.672118459107e-01
+ 4.375000000000e-06 2.672728251259e-01
+ 4.376000000000e-06 2.673338043411e-01
+ 4.377000000000e-06 2.673947835563e-01
+ 4.378000000000e-06 2.674557627715e-01
+ 4.379000000000e-06 2.675167419867e-01
+ 4.380000000000e-06 2.675777212020e-01
+ 4.381000000000e-06 2.676387004172e-01
+ 4.382000000000e-06 2.676996796324e-01
+ 4.383000000000e-06 2.677606588476e-01
+ 4.384000000000e-06 2.678216380628e-01
+ 4.385000000000e-06 2.678826172780e-01
+ 4.386000000000e-06 2.679435964933e-01
+ 4.387000000000e-06 2.680045757085e-01
+ 4.388000000000e-06 2.680655549237e-01
+ 4.389000000000e-06 2.681265341389e-01
+ 4.390000000000e-06 2.681875133541e-01
+ 4.391000000000e-06 2.682484925693e-01
+ 4.392000000000e-06 2.683094717846e-01
+ 4.393000000000e-06 2.683704509998e-01
+ 4.394000000000e-06 2.684314302150e-01
+ 4.395000000000e-06 2.684924094302e-01
+ 4.396000000000e-06 2.685533886454e-01
+ 4.397000000000e-06 2.686143678606e-01
+ 4.398000000000e-06 2.686753470759e-01
+ 4.399000000000e-06 2.687363262911e-01
+ 4.400000000000e-06 2.687973055063e-01
+ 4.401000000000e-06 2.688582847215e-01
+ 4.402000000000e-06 2.689192639367e-01
+ 4.403000000000e-06 2.689802431519e-01
+ 4.404000000000e-06 2.690412223672e-01
+ 4.405000000000e-06 2.691022015824e-01
+ 4.406000000000e-06 2.691631807976e-01
+ 4.407000000000e-06 2.692241600128e-01
+ 4.408000000000e-06 2.692851392280e-01
+ 4.409000000000e-06 2.693461184432e-01
+ 4.410000000000e-06 2.694070976585e-01
+ 4.411000000000e-06 2.694680768737e-01
+ 4.412000000000e-06 2.695290560889e-01
+ 4.413000000000e-06 2.695900353041e-01
+ 4.414000000000e-06 2.696510145193e-01
+ 4.415000000000e-06 2.697119937345e-01
+ 4.416000000000e-06 2.697729729498e-01
+ 4.417000000000e-06 2.698339521650e-01
+ 4.418000000000e-06 2.698949313802e-01
+ 4.419000000000e-06 2.699559105954e-01
+ 4.420000000000e-06 2.700168898106e-01
+ 4.421000000000e-06 2.700778690258e-01
+ 4.422000000000e-06 2.701388482411e-01
+ 4.423000000000e-06 2.701998274563e-01
+ 4.424000000000e-06 2.702608066715e-01
+ 4.425000000000e-06 2.703217858867e-01
+ 4.426000000000e-06 2.703827651019e-01
+ 4.427000000000e-06 2.704437443171e-01
+ 4.428000000000e-06 2.705047235324e-01
+ 4.429000000000e-06 2.705657027476e-01
+ 4.430000000000e-06 2.706266819628e-01
+ 4.431000000000e-06 2.706876611780e-01
+ 4.432000000000e-06 2.707486403932e-01
+ 4.433000000000e-06 2.708096196084e-01
+ 4.434000000000e-06 2.708705988237e-01
+ 4.435000000000e-06 2.709315780389e-01
+ 4.436000000000e-06 2.709925572541e-01
+ 4.437000000000e-06 2.710535364693e-01
+ 4.438000000000e-06 2.711145156845e-01
+ 4.439000000000e-06 2.711754948997e-01
+ 4.440000000000e-06 2.712364741149e-01
+ 4.441000000000e-06 2.712974533302e-01
+ 4.442000000000e-06 2.713584325454e-01
+ 4.443000000000e-06 2.714194117606e-01
+ 4.444000000000e-06 2.714803909758e-01
+ 4.445000000000e-06 2.715413701910e-01
+ 4.446000000000e-06 2.716023494062e-01
+ 4.447000000000e-06 2.716633286215e-01
+ 4.448000000000e-06 2.717243078367e-01
+ 4.449000000000e-06 2.717852870519e-01
+ 4.450000000000e-06 2.718462662671e-01
+ 4.451000000000e-06 2.719072454823e-01
+ 4.452000000000e-06 2.719682246975e-01
+ 4.453000000000e-06 2.720292039128e-01
+ 4.454000000000e-06 2.720901831280e-01
+ 4.455000000000e-06 2.721511623432e-01
+ 4.456000000000e-06 2.722121415584e-01
+ 4.457000000000e-06 2.722731207736e-01
+ 4.458000000000e-06 2.723340999888e-01
+ 4.459000000000e-06 2.723950792041e-01
+ 4.460000000000e-06 2.724560584193e-01
+ 4.461000000000e-06 2.725170376345e-01
+ 4.462000000000e-06 2.725780168497e-01
+ 4.463000000000e-06 2.726389960649e-01
+ 4.464000000000e-06 2.726999752801e-01
+ 4.465000000000e-06 2.727609544954e-01
+ 4.466000000000e-06 2.728219337106e-01
+ 4.467000000000e-06 2.728829129258e-01
+ 4.468000000000e-06 2.729438921410e-01
+ 4.469000000000e-06 2.730048713562e-01
+ 4.470000000000e-06 2.730658505714e-01
+ 4.471000000000e-06 2.731268297867e-01
+ 4.472000000000e-06 2.731878090019e-01
+ 4.473000000000e-06 2.732487882171e-01
+ 4.474000000000e-06 2.733097674323e-01
+ 4.475000000000e-06 2.733707466475e-01
+ 4.476000000000e-06 2.734317258627e-01
+ 4.477000000000e-06 2.734927050780e-01
+ 4.478000000000e-06 2.735536842932e-01
+ 4.479000000000e-06 2.736146635084e-01
+ 4.480000000000e-06 2.736756427236e-01
+ 4.481000000000e-06 2.737366219388e-01
+ 4.482000000000e-06 2.737976011540e-01
+ 4.483000000000e-06 2.738585803693e-01
+ 4.484000000000e-06 2.739195595845e-01
+ 4.485000000000e-06 2.739805387997e-01
+ 4.486000000000e-06 2.740415180149e-01
+ 4.487000000000e-06 2.741024972301e-01
+ 4.488000000000e-06 2.741634764453e-01
+ 4.489000000000e-06 2.742244556606e-01
+ 4.490000000000e-06 2.742854348758e-01
+ 4.491000000000e-06 2.743464140910e-01
+ 4.492000000000e-06 2.744073933062e-01
+ 4.493000000000e-06 2.744683725214e-01
+ 4.494000000000e-06 2.745293517366e-01
+ 4.495000000000e-06 2.745903309519e-01
+ 4.496000000000e-06 2.746513101671e-01
+ 4.497000000000e-06 2.747122893823e-01
+ 4.498000000000e-06 2.747732685975e-01
+ 4.499000000000e-06 2.748342478127e-01
+ 4.500000000000e-06 2.748952270279e-01
+ 4.501000000000e-06 2.749562062432e-01
+ 4.502000000000e-06 2.750171854584e-01
+ 4.503000000000e-06 2.750781646736e-01
+ 4.504000000000e-06 2.751391438888e-01
+ 4.505000000000e-06 2.752001231040e-01
+ 4.506000000000e-06 2.752611023192e-01
+ 4.507000000000e-06 2.753220815345e-01
+ 4.508000000000e-06 2.753830607497e-01
+ 4.509000000000e-06 2.754440399649e-01
+ 4.510000000000e-06 2.755050191801e-01
+ 4.511000000000e-06 2.755659983953e-01
+ 4.512000000000e-06 2.756269776105e-01
+ 4.513000000000e-06 2.756879568258e-01
+ 4.514000000000e-06 2.757489360410e-01
+ 4.515000000000e-06 2.758099152562e-01
+ 4.516000000000e-06 2.758708944714e-01
+ 4.517000000000e-06 2.759318736866e-01
+ 4.518000000000e-06 2.759928529018e-01
+ 4.519000000000e-06 2.760538321171e-01
+ 4.520000000000e-06 2.761148113323e-01
+ 4.521000000000e-06 2.761757905475e-01
+ 4.522000000000e-06 2.762367697627e-01
+ 4.523000000000e-06 2.762977489779e-01
+ 4.524000000000e-06 2.763587281931e-01
+ 4.525000000000e-06 2.764197074084e-01
+ 4.526000000000e-06 2.764806866236e-01
+ 4.527000000000e-06 2.765416658388e-01
+ 4.528000000000e-06 2.766026450540e-01
+ 4.529000000000e-06 2.766636242692e-01
+ 4.530000000000e-06 2.767246034844e-01
+ 4.531000000000e-06 2.767855826997e-01
+ 4.532000000000e-06 2.768465619149e-01
+ 4.533000000000e-06 2.769075411301e-01
+ 4.534000000000e-06 2.769685203453e-01
+ 4.535000000000e-06 2.770294995605e-01
+ 4.536000000000e-06 2.770904787757e-01
+ 4.537000000000e-06 2.771514579910e-01
+ 4.538000000000e-06 2.772124372062e-01
+ 4.539000000000e-06 2.772734164214e-01
+ 4.540000000000e-06 2.773343956366e-01
+ 4.541000000000e-06 2.773953748518e-01
+ 4.542000000000e-06 2.774563540670e-01
+ 4.543000000000e-06 2.775173332823e-01
+ 4.544000000000e-06 2.775783124975e-01
+ 4.545000000000e-06 2.776392917127e-01
+ 4.546000000000e-06 2.777002709279e-01
+ 4.547000000000e-06 2.777612501431e-01
+ 4.548000000000e-06 2.778222293583e-01
+ 4.549000000000e-06 2.778832085736e-01
+ 4.550000000000e-06 2.779441877888e-01
+ 4.551000000000e-06 2.780051670040e-01
+ 4.552000000000e-06 2.780661462192e-01
+ 4.553000000000e-06 2.781271254344e-01
+ 4.554000000000e-06 2.781881046496e-01
+ 4.555000000000e-06 2.782490838649e-01
+ 4.556000000000e-06 2.783100630801e-01
+ 4.557000000000e-06 2.783710422953e-01
+ 4.558000000000e-06 2.784320215105e-01
+ 4.559000000000e-06 2.784930007257e-01
+ 4.560000000000e-06 2.785539799409e-01
+ 4.561000000000e-06 2.786149591562e-01
+ 4.562000000000e-06 2.786759383714e-01
+ 4.563000000000e-06 2.787369175866e-01
+ 4.564000000000e-06 2.787978968018e-01
+ 4.565000000000e-06 2.788588760170e-01
+ 4.566000000000e-06 2.789198552322e-01
+ 4.567000000000e-06 2.789808344475e-01
+ 4.568000000000e-06 2.790418136627e-01
+ 4.569000000000e-06 2.791027928779e-01
+ 4.570000000000e-06 2.791637720931e-01
+ 4.571000000000e-06 2.792247513083e-01
+ 4.572000000000e-06 2.792857305235e-01
+ 4.573000000000e-06 2.793467097388e-01
+ 4.574000000000e-06 2.794076889540e-01
+ 4.575000000000e-06 2.794686681692e-01
+ 4.576000000000e-06 2.795296473844e-01
+ 4.577000000000e-06 2.795906265996e-01
+ 4.578000000000e-06 2.796516058148e-01
+ 4.579000000000e-06 2.797125850301e-01
+ 4.580000000000e-06 2.797735642453e-01
+ 4.581000000000e-06 2.798345434605e-01
+ 4.582000000000e-06 2.798955226757e-01
+ 4.583000000000e-06 2.799565018909e-01
+ 4.584000000000e-06 2.800174811061e-01
+ 4.585000000000e-06 2.800784603214e-01
+ 4.586000000000e-06 2.801394395366e-01
+ 4.587000000000e-06 2.802004187518e-01
+ 4.588000000000e-06 2.802613979670e-01
+ 4.589000000000e-06 2.803223771822e-01
+ 4.590000000000e-06 2.803833563974e-01
+ 4.591000000000e-06 2.804443356127e-01
+ 4.592000000000e-06 2.805053148279e-01
+ 4.593000000000e-06 2.805662940431e-01
+ 4.594000000000e-06 2.806272732583e-01
+ 4.595000000000e-06 2.806882524735e-01
+ 4.596000000000e-06 2.807492316887e-01
+ 4.597000000000e-06 2.808102109040e-01
+ 4.598000000000e-06 2.808711901192e-01
+ 4.599000000000e-06 2.809321693344e-01
+ 4.600000000000e-06 2.809931485496e-01
+ 4.601000000000e-06 2.810541277648e-01
+ 4.602000000000e-06 2.811151069800e-01
+ 4.603000000000e-06 2.811760861953e-01
+ 4.604000000000e-06 2.812370654105e-01
+ 4.605000000000e-06 2.812980446257e-01
+ 4.606000000000e-06 2.813590238409e-01
+ 4.607000000000e-06 2.814200030561e-01
+ 4.608000000000e-06 2.814809822713e-01
+ 4.609000000000e-06 2.815419614866e-01
+ 4.610000000000e-06 2.816029407018e-01
+ 4.611000000000e-06 2.816639199170e-01
+ 4.612000000000e-06 2.817248991322e-01
+ 4.613000000000e-06 2.817858783474e-01
+ 4.614000000000e-06 2.818468575626e-01
+ 4.615000000000e-06 2.819078367779e-01
+ 4.616000000000e-06 2.819688159931e-01
+ 4.617000000000e-06 2.820297952083e-01
+ 4.618000000000e-06 2.820907744235e-01
+ 4.619000000000e-06 2.821517536387e-01
+ 4.620000000000e-06 2.822127328539e-01
+ 4.621000000000e-06 2.822737120692e-01
+ 4.622000000000e-06 2.823346912844e-01
+ 4.623000000000e-06 2.823956704996e-01
+ 4.624000000000e-06 2.824566497148e-01
+ 4.625000000000e-06 2.825176289300e-01
+ 4.626000000000e-06 2.825786081452e-01
+ 4.627000000000e-06 2.826395873605e-01
+ 4.628000000000e-06 2.827005665757e-01
+ 4.629000000000e-06 2.827615457909e-01
+ 4.630000000000e-06 2.828225250061e-01
+ 4.631000000000e-06 2.828835042213e-01
+ 4.632000000000e-06 2.829444834365e-01
+ 4.633000000000e-06 2.830054626518e-01
+ 4.634000000000e-06 2.830664418670e-01
+ 4.635000000000e-06 2.831274210822e-01
+ 4.636000000000e-06 2.831884002974e-01
+ 4.637000000000e-06 2.832493795126e-01
+ 4.638000000000e-06 2.833103587278e-01
+ 4.639000000000e-06 2.833713379431e-01
+ 4.640000000000e-06 2.834323171583e-01
+ 4.641000000000e-06 2.834932963735e-01
+ 4.642000000000e-06 2.835542755887e-01
+ 4.643000000000e-06 2.836152548039e-01
+ 4.644000000000e-06 2.836762340191e-01
+ 4.645000000000e-06 2.837372132344e-01
+ 4.646000000000e-06 2.837981924496e-01
+ 4.647000000000e-06 2.838591716648e-01
+ 4.648000000000e-06 2.839201508800e-01
+ 4.649000000000e-06 2.839811300952e-01
+ 4.650000000000e-06 2.840421093104e-01
+ 4.651000000000e-06 2.841030885257e-01
+ 4.652000000000e-06 2.841640677409e-01
+ 4.653000000000e-06 2.842250469561e-01
+ 4.654000000000e-06 2.842860261713e-01
+ 4.655000000000e-06 2.843470053865e-01
+ 4.656000000000e-06 2.844079846017e-01
+ 4.657000000000e-06 2.844689638170e-01
+ 4.658000000000e-06 2.845299430322e-01
+ 4.659000000000e-06 2.845909222474e-01
+ 4.660000000000e-06 2.846519014626e-01
+ 4.661000000000e-06 2.847128806778e-01
+ 4.662000000000e-06 2.847738598930e-01
+ 4.663000000000e-06 2.848348391082e-01
+ 4.664000000000e-06 2.848958183235e-01
+ 4.665000000000e-06 2.849567975387e-01
+ 4.666000000000e-06 2.850177767539e-01
+ 4.667000000000e-06 2.850787559691e-01
+ 4.668000000000e-06 2.851397351843e-01
+ 4.669000000000e-06 2.852007143995e-01
+ 4.670000000000e-06 2.852616936148e-01
+ 4.671000000000e-06 2.853226728300e-01
+ 4.672000000000e-06 2.853836520452e-01
+ 4.673000000000e-06 2.854446312604e-01
+ 4.674000000000e-06 2.855056104756e-01
+ 4.675000000000e-06 2.855665896908e-01
+ 4.676000000000e-06 2.856275689061e-01
+ 4.677000000000e-06 2.856885481213e-01
+ 4.678000000000e-06 2.857495273365e-01
+ 4.679000000000e-06 2.858105065517e-01
+ 4.680000000000e-06 2.858714857669e-01
+ 4.681000000000e-06 2.859324649821e-01
+ 4.682000000000e-06 2.859934441974e-01
+ 4.683000000000e-06 2.860544234126e-01
+ 4.684000000000e-06 2.861154026278e-01
+ 4.685000000000e-06 2.861763818430e-01
+ 4.686000000000e-06 2.862373610582e-01
+ 4.687000000000e-06 2.862983402734e-01
+ 4.688000000000e-06 2.863593194887e-01
+ 4.689000000000e-06 2.864202987039e-01
+ 4.690000000000e-06 2.864812779191e-01
+ 4.691000000000e-06 2.865422571343e-01
+ 4.692000000000e-06 2.866032363495e-01
+ 4.693000000000e-06 2.866642155647e-01
+ 4.694000000000e-06 2.867251947800e-01
+ 4.695000000000e-06 2.867861739952e-01
+ 4.696000000000e-06 2.868471532104e-01
+ 4.697000000000e-06 2.869081324256e-01
+ 4.698000000000e-06 2.869691116408e-01
+ 4.699000000000e-06 2.870300908560e-01
+ 4.700000000000e-06 2.870910700713e-01
+ 4.701000000000e-06 2.871520492865e-01
+ 4.702000000000e-06 2.872130285017e-01
+ 4.703000000000e-06 2.872740077169e-01
+ 4.704000000000e-06 2.873349869321e-01
+ 4.705000000000e-06 2.873959661473e-01
+ 4.706000000000e-06 2.874569453626e-01
+ 4.707000000000e-06 2.875179245778e-01
+ 4.708000000000e-06 2.875789037930e-01
+ 4.709000000000e-06 2.876398830082e-01
+ 4.710000000000e-06 2.877008622234e-01
+ 4.711000000000e-06 2.877618414386e-01
+ 4.712000000000e-06 2.878228206539e-01
+ 4.713000000000e-06 2.878837998691e-01
+ 4.714000000000e-06 2.879447790843e-01
+ 4.715000000000e-06 2.880057582995e-01
+ 4.716000000000e-06 2.880667375147e-01
+ 4.717000000000e-06 2.881277167299e-01
+ 4.718000000000e-06 2.881886959452e-01
+ 4.719000000000e-06 2.882496751604e-01
+ 4.720000000000e-06 2.883106543756e-01
+ 4.721000000000e-06 2.883716335908e-01
+ 4.722000000000e-06 2.884326128060e-01
+ 4.723000000000e-06 2.884935920212e-01
+ 4.724000000000e-06 2.885545712365e-01
+ 4.725000000000e-06 2.886155504517e-01
+ 4.726000000000e-06 2.886765296669e-01
+ 4.727000000000e-06 2.887375088821e-01
+ 4.728000000000e-06 2.887984880973e-01
+ 4.729000000000e-06 2.888594673125e-01
+ 4.730000000000e-06 2.889204465278e-01
+ 4.731000000000e-06 2.889814257430e-01
+ 4.732000000000e-06 2.890424049582e-01
+ 4.733000000000e-06 2.891033841734e-01
+ 4.734000000000e-06 2.891643633886e-01
+ 4.735000000000e-06 2.892253426038e-01
+ 4.736000000000e-06 2.892863218191e-01
+ 4.737000000000e-06 2.893473010343e-01
+ 4.738000000000e-06 2.894082802495e-01
+ 4.739000000000e-06 2.894692594647e-01
+ 4.740000000000e-06 2.895302386799e-01
+ 4.741000000000e-06 2.895912178951e-01
+ 4.742000000000e-06 2.896521971104e-01
+ 4.743000000000e-06 2.897131763256e-01
+ 4.744000000000e-06 2.897741555408e-01
+ 4.745000000000e-06 2.898351347560e-01
+ 4.746000000000e-06 2.898961139712e-01
+ 4.747000000000e-06 2.899570931864e-01
+ 4.748000000000e-06 2.900180724017e-01
+ 4.749000000000e-06 2.900790516169e-01
+ 4.750000000000e-06 2.901400308321e-01
+ 4.751000000000e-06 2.902010100473e-01
+ 4.752000000000e-06 2.902619892625e-01
+ 4.753000000000e-06 2.903229684777e-01
+ 4.754000000000e-06 2.903839476930e-01
+ 4.755000000000e-06 2.904449269082e-01
+ 4.756000000000e-06 2.905059061234e-01
+ 4.757000000000e-06 2.905668853386e-01
+ 4.758000000000e-06 2.906278645538e-01
+ 4.759000000000e-06 2.906888437690e-01
+ 4.760000000000e-06 2.907498229843e-01
+ 4.761000000000e-06 2.908108021995e-01
+ 4.762000000000e-06 2.908717814147e-01
+ 4.763000000000e-06 2.909327606299e-01
+ 4.764000000000e-06 2.909937398451e-01
+ 4.765000000000e-06 2.910547190603e-01
+ 4.766000000000e-06 2.911156982756e-01
+ 4.767000000000e-06 2.911766774908e-01
+ 4.768000000000e-06 2.912376567060e-01
+ 4.769000000000e-06 2.912986359212e-01
+ 4.770000000000e-06 2.913596151364e-01
+ 4.771000000000e-06 2.914205943516e-01
+ 4.772000000000e-06 2.914815735669e-01
+ 4.773000000000e-06 2.915425527821e-01
+ 4.774000000000e-06 2.916035319973e-01
+ 4.775000000000e-06 2.916645112125e-01
+ 4.776000000000e-06 2.917254904277e-01
+ 4.777000000000e-06 2.917864696429e-01
+ 4.778000000000e-06 2.918474488582e-01
+ 4.779000000000e-06 2.919084280734e-01
+ 4.780000000000e-06 2.919694072886e-01
+ 4.781000000000e-06 2.920303865038e-01
+ 4.782000000000e-06 2.920913657190e-01
+ 4.783000000000e-06 2.921523449342e-01
+ 4.784000000000e-06 2.922133241495e-01
+ 4.785000000000e-06 2.922743033647e-01
+ 4.786000000000e-06 2.923352825799e-01
+ 4.787000000000e-06 2.923962617951e-01
+ 4.788000000000e-06 2.924572410103e-01
+ 4.789000000000e-06 2.925182202255e-01
+ 4.790000000000e-06 2.925791994408e-01
+ 4.791000000000e-06 2.926401786560e-01
+ 4.792000000000e-06 2.927011578712e-01
+ 4.793000000000e-06 2.927621370864e-01
+ 4.794000000000e-06 2.928231163016e-01
+ 4.795000000000e-06 2.928840955168e-01
+ 4.796000000000e-06 2.929450747321e-01
+ 4.797000000000e-06 2.930060539473e-01
+ 4.798000000000e-06 2.930670331625e-01
+ 4.799000000000e-06 2.931280123777e-01
+ 4.800000000000e-06 2.931889915929e-01
+ 4.801000000000e-06 2.932499708081e-01
+ 4.802000000000e-06 2.933109500234e-01
+ 4.803000000000e-06 2.933719292386e-01
+ 4.804000000000e-06 2.934329084538e-01
+ 4.805000000000e-06 2.934938876690e-01
+ 4.806000000000e-06 2.935548668842e-01
+ 4.807000000000e-06 2.936158460994e-01
+ 4.808000000000e-06 2.936768253147e-01
+ 4.809000000000e-06 2.937378045299e-01
+ 4.810000000000e-06 2.937987837451e-01
+ 4.811000000000e-06 2.938597629603e-01
+ 4.812000000000e-06 2.939207421755e-01
+ 4.813000000000e-06 2.939817213907e-01
+ 4.814000000000e-06 2.940427006060e-01
+ 4.815000000000e-06 2.941036798212e-01
+ 4.816000000000e-06 2.941646590364e-01
+ 4.817000000000e-06 2.942256382516e-01
+ 4.818000000000e-06 2.942866174668e-01
+ 4.819000000000e-06 2.943475966820e-01
+ 4.820000000000e-06 2.944085758973e-01
+ 4.821000000000e-06 2.944695551125e-01
+ 4.822000000000e-06 2.945305343277e-01
+ 4.823000000000e-06 2.945915135429e-01
+ 4.824000000000e-06 2.946524927581e-01
+ 4.825000000000e-06 2.947134719733e-01
+ 4.826000000000e-06 2.947744511886e-01
+ 4.827000000000e-06 2.948354304038e-01
+ 4.828000000000e-06 2.948964096190e-01
+ 4.829000000000e-06 2.949573888342e-01
+ 4.830000000000e-06 2.950183680494e-01
+ 4.831000000000e-06 2.950793472646e-01
+ 4.832000000000e-06 2.951403264799e-01
+ 4.833000000000e-06 2.952013056951e-01
+ 4.834000000000e-06 2.952622849103e-01
+ 4.835000000000e-06 2.953232641255e-01
+ 4.836000000000e-06 2.953842433407e-01
+ 4.837000000000e-06 2.954452225559e-01
+ 4.838000000000e-06 2.955062017712e-01
+ 4.839000000000e-06 2.955671809864e-01
+ 4.840000000000e-06 2.956281602016e-01
+ 4.841000000000e-06 2.956891394168e-01
+ 4.842000000000e-06 2.957501186320e-01
+ 4.843000000000e-06 2.958110978472e-01
+ 4.844000000000e-06 2.958720770625e-01
+ 4.845000000000e-06 2.959330562777e-01
+ 4.846000000000e-06 2.959940354929e-01
+ 4.847000000000e-06 2.960550147081e-01
+ 4.848000000000e-06 2.961159939233e-01
+ 4.849000000000e-06 2.961769731385e-01
+ 4.850000000000e-06 2.962379523538e-01
+ 4.851000000000e-06 2.962989315690e-01
+ 4.852000000000e-06 2.963599107842e-01
+ 4.853000000000e-06 2.964208899994e-01
+ 4.854000000000e-06 2.964818692146e-01
+ 4.855000000000e-06 2.965428484298e-01
+ 4.856000000000e-06 2.966038276451e-01
+ 4.857000000000e-06 2.966648068603e-01
+ 4.858000000000e-06 2.967257860755e-01
+ 4.859000000000e-06 2.967867652907e-01
+ 4.860000000000e-06 2.968477445059e-01
+ 4.861000000000e-06 2.969087237211e-01
+ 4.862000000000e-06 2.969697029364e-01
+ 4.863000000000e-06 2.970306821516e-01
+ 4.864000000000e-06 2.970916613668e-01
+ 4.865000000000e-06 2.971526405820e-01
+ 4.866000000000e-06 2.972136197972e-01
+ 4.867000000000e-06 2.972745990124e-01
+ 4.868000000000e-06 2.973355782277e-01
+ 4.869000000000e-06 2.973965574429e-01
+ 4.870000000000e-06 2.974575366581e-01
+ 4.871000000000e-06 2.975185158733e-01
+ 4.872000000000e-06 2.975794950885e-01
+ 4.873000000000e-06 2.976404743037e-01
+ 4.874000000000e-06 2.977014535190e-01
+ 4.875000000000e-06 2.977624327342e-01
+ 4.876000000000e-06 2.978234119494e-01
+ 4.877000000000e-06 2.978843911646e-01
+ 4.878000000000e-06 2.979453703798e-01
+ 4.879000000000e-06 2.980063495950e-01
+ 4.880000000000e-06 2.980673288103e-01
+ 4.881000000000e-06 2.981283080255e-01
+ 4.882000000000e-06 2.981892872407e-01
+ 4.883000000000e-06 2.982502664559e-01
+ 4.884000000000e-06 2.983112456711e-01
+ 4.885000000000e-06 2.983722248863e-01
+ 4.886000000000e-06 2.984332041016e-01
+ 4.887000000000e-06 2.984941833168e-01
+ 4.888000000000e-06 2.985551625320e-01
+ 4.889000000000e-06 2.986161417472e-01
+ 4.890000000000e-06 2.986771209624e-01
+ 4.891000000000e-06 2.987381001776e-01
+ 4.892000000000e-06 2.987990793928e-01
+ 4.893000000000e-06 2.988600586081e-01
+ 4.894000000000e-06 2.989210378233e-01
+ 4.895000000000e-06 2.989820170385e-01
+ 4.896000000000e-06 2.990429962537e-01
+ 4.897000000000e-06 2.991039754689e-01
+ 4.898000000000e-06 2.991649546841e-01
+ 4.899000000000e-06 2.992259338994e-01
+ 4.900000000000e-06 2.992869131146e-01
+ 4.901000000000e-06 2.993478923298e-01
+ 4.902000000000e-06 2.994088715450e-01
+ 4.903000000000e-06 2.994698507602e-01
+ 4.904000000000e-06 2.995308299754e-01
+ 4.905000000000e-06 2.995918091907e-01
+ 4.906000000000e-06 2.996527884059e-01
+ 4.907000000000e-06 2.997137676211e-01
+ 4.908000000000e-06 2.997747468363e-01
+ 4.909000000000e-06 2.998357260515e-01
+ 4.910000000000e-06 2.998967052667e-01
+ 4.911000000000e-06 2.999576844820e-01
+ 4.912000000000e-06 3.000186636972e-01
+ 4.913000000000e-06 3.000796429124e-01
+ 4.914000000000e-06 3.001406221276e-01
+ 4.915000000000e-06 3.002016013428e-01
+ 4.916000000000e-06 3.002625805580e-01
+ 4.917000000000e-06 3.003235597733e-01
+ 4.918000000000e-06 3.003845389885e-01
+ 4.919000000000e-06 3.004455182037e-01
+ 4.920000000000e-06 3.005064974189e-01
+ 4.921000000000e-06 3.005674766341e-01
+ 4.922000000000e-06 3.006284558493e-01
+ 4.923000000000e-06 3.006894350646e-01
+ 4.924000000000e-06 3.007504142798e-01
+ 4.925000000000e-06 3.008113934950e-01
+ 4.926000000000e-06 3.008723727102e-01
+ 4.927000000000e-06 3.009333519254e-01
+ 4.928000000000e-06 3.009943311406e-01
+ 4.929000000000e-06 3.010553103559e-01
+ 4.930000000000e-06 3.011162895711e-01
+ 4.931000000000e-06 3.011772687863e-01
+ 4.932000000000e-06 3.012382480015e-01
+ 4.933000000000e-06 3.012992272167e-01
+ 4.934000000000e-06 3.013602064319e-01
+ 4.935000000000e-06 3.014211856472e-01
+ 4.936000000000e-06 3.014821648624e-01
+ 4.937000000000e-06 3.015431440776e-01
+ 4.938000000000e-06 3.016041232928e-01
+ 4.939000000000e-06 3.016651025080e-01
+ 4.940000000000e-06 3.017260817232e-01
+ 4.941000000000e-06 3.017870609385e-01
+ 4.942000000000e-06 3.018480401537e-01
+ 4.943000000000e-06 3.019090193689e-01
+ 4.944000000000e-06 3.019699985841e-01
+ 4.945000000000e-06 3.020309777993e-01
+ 4.946000000000e-06 3.020919570145e-01
+ 4.947000000000e-06 3.021529362298e-01
+ 4.948000000000e-06 3.022139154450e-01
+ 4.949000000000e-06 3.022748946602e-01
+ 4.950000000000e-06 3.023358738754e-01
+ 4.951000000000e-06 3.023968530906e-01
+ 4.952000000000e-06 3.024578323058e-01
+ 4.953000000000e-06 3.025188115211e-01
+ 4.954000000000e-06 3.025797907363e-01
+ 4.955000000000e-06 3.026407699515e-01
+ 4.956000000000e-06 3.027017491667e-01
+ 4.957000000000e-06 3.027627283819e-01
+ 4.958000000000e-06 3.028237075971e-01
+ 4.959000000000e-06 3.028846868124e-01
+ 4.960000000000e-06 3.029456660276e-01
+ 4.961000000000e-06 3.030066452428e-01
+ 4.962000000000e-06 3.030676244580e-01
+ 4.963000000000e-06 3.031286036732e-01
+ 4.964000000000e-06 3.031895828884e-01
+ 4.965000000000e-06 3.032505621037e-01
+ 4.966000000000e-06 3.033115413189e-01
+ 4.967000000000e-06 3.033725205341e-01
+ 4.968000000000e-06 3.034334997493e-01
+ 4.969000000000e-06 3.034944789645e-01
+ 4.970000000000e-06 3.035554581797e-01
+ 4.971000000000e-06 3.036164373950e-01
+ 4.972000000000e-06 3.036774166102e-01
+ 4.973000000000e-06 3.037383958254e-01
+ 4.974000000000e-06 3.037993750406e-01
+ 4.975000000000e-06 3.038603542558e-01
+ 4.976000000000e-06 3.039213334710e-01
+ 4.977000000000e-06 3.039823126863e-01
+ 4.978000000000e-06 3.040432919015e-01
+ 4.979000000000e-06 3.041042711167e-01
+ 4.980000000000e-06 3.041652503319e-01
+ 4.981000000000e-06 3.042262295471e-01
+ 4.982000000000e-06 3.042872087623e-01
+ 4.983000000000e-06 3.043481879776e-01
+ 4.984000000000e-06 3.044091671928e-01
+ 4.985000000000e-06 3.044701464080e-01
+ 4.986000000000e-06 3.045311256232e-01
+ 4.987000000000e-06 3.045921048384e-01
+ 4.988000000000e-06 3.046530840536e-01
+ 4.989000000000e-06 3.047140632689e-01
+ 4.990000000000e-06 3.047750424841e-01
+ 4.991000000000e-06 3.048360216993e-01
+ 4.992000000000e-06 3.048970009145e-01
+ 4.993000000000e-06 3.049579801297e-01
+ 4.994000000000e-06 3.050189593449e-01
+ 4.995000000000e-06 3.050799385602e-01
+ 4.996000000000e-06 3.051409177754e-01
+ 4.997000000000e-06 3.052018969906e-01
+ 4.998000000000e-06 3.052628762058e-01
+ 4.999000000000e-06 3.053238554210e-01
+ 5.000000000000e-06 3.053848346362e-01
+ 5.001000000000e-06 3.054458138515e-01
+ 5.002000000000e-06 3.055067930667e-01
+ 5.003000000000e-06 3.055677722819e-01
+ 5.004000000000e-06 3.056287514971e-01
+ 5.005000000000e-06 3.056897307123e-01
+ 5.006000000000e-06 3.057507099275e-01
+ 5.007000000000e-06 3.058116891428e-01
+ 5.008000000000e-06 3.058726683580e-01
+ 5.009000000000e-06 3.059336475732e-01
+ 5.010000000000e-06 3.059946267884e-01
+ 5.011000000000e-06 3.060556060036e-01
+ 5.012000000000e-06 3.061165852188e-01
+ 5.013000000000e-06 3.061775644341e-01
+ 5.014000000000e-06 3.062385436493e-01
+ 5.015000000000e-06 3.062995228645e-01
+ 5.016000000000e-06 3.063605020797e-01
+ 5.017000000000e-06 3.064214812949e-01
+ 5.018000000000e-06 3.064824605101e-01
+ 5.019000000000e-06 3.065434397254e-01
+ 5.020000000000e-06 3.066044189406e-01
+ 5.021000000000e-06 3.066653981558e-01
+ 5.022000000000e-06 3.067263773710e-01
+ 5.023000000000e-06 3.067873565862e-01
+ 5.024000000000e-06 3.068483358014e-01
+ 5.025000000000e-06 3.069093150167e-01
+ 5.026000000000e-06 3.069702942319e-01
+ 5.027000000000e-06 3.070312734471e-01
+ 5.028000000000e-06 3.070922526623e-01
+ 5.029000000000e-06 3.071532318775e-01
+ 5.030000000000e-06 3.072142110927e-01
+ 5.031000000000e-06 3.072751903080e-01
+ 5.032000000000e-06 3.073361695232e-01
+ 5.033000000000e-06 3.073971487384e-01
+ 5.034000000000e-06 3.074581279536e-01
+ 5.035000000000e-06 3.075191071688e-01
+ 5.036000000000e-06 3.075800863840e-01
+ 5.037000000000e-06 3.076410655993e-01
+ 5.038000000000e-06 3.077020448145e-01
+ 5.039000000000e-06 3.077630240297e-01
+ 5.040000000000e-06 3.078240032449e-01
+ 5.041000000000e-06 3.078849824601e-01
+ 5.042000000000e-06 3.079459616753e-01
+ 5.043000000000e-06 3.080069408906e-01
+ 5.044000000000e-06 3.080679201058e-01
+ 5.045000000000e-06 3.081288993210e-01
+ 5.046000000000e-06 3.081898785362e-01
+ 5.047000000000e-06 3.082508577514e-01
+ 5.048000000000e-06 3.083118369666e-01
+ 5.049000000000e-06 3.083728161819e-01
+ 5.050000000000e-06 3.084337953971e-01
+ 5.051000000000e-06 3.084947746123e-01
+ 5.052000000000e-06 3.085557538275e-01
+ 5.053000000000e-06 3.086167330427e-01
+ 5.054000000000e-06 3.086777122579e-01
+ 5.055000000000e-06 3.087386914732e-01
+ 5.056000000000e-06 3.087996706884e-01
+ 5.057000000000e-06 3.088606499036e-01
+ 5.058000000000e-06 3.089216291188e-01
+ 5.059000000000e-06 3.089826083340e-01
+ 5.060000000000e-06 3.090435875492e-01
+ 5.061000000000e-06 3.091045667645e-01
+ 5.062000000000e-06 3.091655459797e-01
+ 5.063000000000e-06 3.092265251949e-01
+ 5.064000000000e-06 3.092875044101e-01
+ 5.065000000000e-06 3.093484836253e-01
+ 5.066000000000e-06 3.094094628405e-01
+ 5.067000000000e-06 3.094704420558e-01
+ 5.068000000000e-06 3.095314212710e-01
+ 5.069000000000e-06 3.095924004862e-01
+ 5.070000000000e-06 3.096533797014e-01
+ 5.071000000000e-06 3.097143589166e-01
+ 5.072000000000e-06 3.097753381318e-01
+ 5.073000000000e-06 3.098363173471e-01
+ 5.074000000000e-06 3.098972965623e-01
+ 5.075000000000e-06 3.099582757775e-01
+ 5.076000000000e-06 3.100192549927e-01
+ 5.077000000000e-06 3.100802342079e-01
+ 5.078000000000e-06 3.101412134231e-01
+ 5.079000000000e-06 3.102021926384e-01
+ 5.080000000000e-06 3.102631718536e-01
+ 5.081000000000e-06 3.103241510688e-01
+ 5.082000000000e-06 3.103851302840e-01
+ 5.083000000000e-06 3.104461094992e-01
+ 5.084000000000e-06 3.105070887144e-01
+ 5.085000000000e-06 3.105680679297e-01
+ 5.086000000000e-06 3.106290471449e-01
+ 5.087000000000e-06 3.106900263601e-01
+ 5.088000000000e-06 3.107510055753e-01
+ 5.089000000000e-06 3.108119847905e-01
+ 5.090000000000e-06 3.108729640057e-01
+ 5.091000000000e-06 3.109339432210e-01
+ 5.092000000000e-06 3.109949224362e-01
+ 5.093000000000e-06 3.110559016514e-01
+ 5.094000000000e-06 3.111168808666e-01
+ 5.095000000000e-06 3.111778600818e-01
+ 5.096000000000e-06 3.112388392970e-01
+ 5.097000000000e-06 3.112998185123e-01
+ 5.098000000000e-06 3.113607977275e-01
+ 5.099000000000e-06 3.114217769427e-01
+ 5.100000000000e-06 3.114827561579e-01
+ 5.101000000000e-06 3.115437353731e-01
+ 5.102000000000e-06 3.116047145883e-01
+ 5.103000000000e-06 3.116656938036e-01
+ 5.104000000000e-06 3.117266730188e-01
+ 5.105000000000e-06 3.117876522340e-01
+ 5.106000000000e-06 3.118486314492e-01
+ 5.107000000000e-06 3.119096106644e-01
+ 5.108000000000e-06 3.119705898796e-01
+ 5.109000000000e-06 3.120315690949e-01
+ 5.110000000000e-06 3.120925483101e-01
+ 5.111000000000e-06 3.121535275253e-01
+ 5.112000000000e-06 3.122145067405e-01
+ 5.113000000000e-06 3.122754859557e-01
+ 5.114000000000e-06 3.123364651709e-01
+ 5.115000000000e-06 3.123974443862e-01
+ 5.116000000000e-06 3.124584236014e-01
+ 5.117000000000e-06 3.125194028166e-01
+ 5.118000000000e-06 3.125803820318e-01
+ 5.119000000000e-06 3.126413612470e-01
+ 5.120000000000e-06 3.127023404622e-01
+ 5.121000000000e-06 3.127633196774e-01
+ 5.122000000000e-06 3.128242988927e-01
+ 5.123000000000e-06 3.128852781079e-01
+ 5.124000000000e-06 3.129462573231e-01
+ 5.125000000000e-06 3.130072365383e-01
+ 5.126000000000e-06 3.130682157535e-01
+ 5.127000000000e-06 3.131291949687e-01
+ 5.128000000000e-06 3.131901741840e-01
+ 5.129000000000e-06 3.132511533992e-01
+ 5.130000000000e-06 3.133121326144e-01
+ 5.131000000000e-06 3.133731118296e-01
+ 5.132000000000e-06 3.134340910448e-01
+ 5.133000000000e-06 3.134950702600e-01
+ 5.134000000000e-06 3.135560494753e-01
+ 5.135000000000e-06 3.136170286905e-01
+ 5.136000000000e-06 3.136780079057e-01
+ 5.137000000000e-06 3.137389871209e-01
+ 5.138000000000e-06 3.137999663361e-01
+ 5.139000000000e-06 3.138609455513e-01
+ 5.140000000000e-06 3.139219247666e-01
+ 5.141000000000e-06 3.139829039818e-01
+ 5.142000000000e-06 3.140438831970e-01
+ 5.143000000000e-06 3.141048624122e-01
+ 5.144000000000e-06 3.141658416274e-01
+ 5.145000000000e-06 3.142268208426e-01
+ 5.146000000000e-06 3.142878000579e-01
+ 5.147000000000e-06 3.143487792731e-01
+ 5.148000000000e-06 3.144097584883e-01
+ 5.149000000000e-06 3.144707377035e-01
+ 5.150000000000e-06 3.145317169187e-01
+ 5.151000000000e-06 3.145926961339e-01
+ 5.152000000000e-06 3.146536753492e-01
+ 5.153000000000e-06 3.147146545644e-01
+ 5.154000000000e-06 3.147756337796e-01
+ 5.155000000000e-06 3.148366129948e-01
+ 5.156000000000e-06 3.148975922100e-01
+ 5.157000000000e-06 3.149585714252e-01
+ 5.158000000000e-06 3.150195506405e-01
+ 5.159000000000e-06 3.150805298557e-01
+ 5.160000000000e-06 3.151415090709e-01
+ 5.161000000000e-06 3.152024882861e-01
+ 5.162000000000e-06 3.152634675013e-01
+ 5.163000000000e-06 3.153244467165e-01
+ 5.164000000000e-06 3.153854259318e-01
+ 5.165000000000e-06 3.154464051470e-01
+ 5.166000000000e-06 3.155073843622e-01
+ 5.167000000000e-06 3.155683635774e-01
+ 5.168000000000e-06 3.156293427926e-01
+ 5.169000000000e-06 3.156903220078e-01
+ 5.170000000000e-06 3.157513012231e-01
+ 5.171000000000e-06 3.158122804383e-01
+ 5.172000000000e-06 3.158732596535e-01
+ 5.173000000000e-06 3.159342388687e-01
+ 5.174000000000e-06 3.159952180839e-01
+ 5.175000000000e-06 3.160561972991e-01
+ 5.176000000000e-06 3.161171765144e-01
+ 5.177000000000e-06 3.161781557296e-01
+ 5.178000000000e-06 3.162391349448e-01
+ 5.179000000000e-06 3.163001141600e-01
+ 5.180000000000e-06 3.163610933752e-01
+ 5.181000000000e-06 3.164220725904e-01
+ 5.182000000000e-06 3.164830518057e-01
+ 5.183000000000e-06 3.165440310209e-01
+ 5.184000000000e-06 3.166050102361e-01
+ 5.185000000000e-06 3.166659894513e-01
+ 5.186000000000e-06 3.167269686665e-01
+ 5.187000000000e-06 3.167879478817e-01
+ 5.188000000000e-06 3.168489270970e-01
+ 5.189000000000e-06 3.169099063122e-01
+ 5.190000000000e-06 3.169708855274e-01
+ 5.191000000000e-06 3.170318647426e-01
+ 5.192000000000e-06 3.170928439578e-01
+ 5.193000000000e-06 3.171538231730e-01
+ 5.194000000000e-06 3.172148023883e-01
+ 5.195000000000e-06 3.172757816035e-01
+ 5.196000000000e-06 3.173367608187e-01
+ 5.197000000000e-06 3.173977400339e-01
+ 5.198000000000e-06 3.174587192491e-01
+ 5.199000000000e-06 3.175196984643e-01
+ 5.200000000000e-06 3.175806776796e-01
+ 5.201000000000e-06 3.176416568948e-01
+ 5.202000000000e-06 3.177026361100e-01
+ 5.203000000000e-06 3.177636153252e-01
+ 5.204000000000e-06 3.178245945404e-01
+ 5.205000000000e-06 3.178855737556e-01
+ 5.206000000000e-06 3.179465529709e-01
+ 5.207000000000e-06 3.180075321861e-01
+ 5.208000000000e-06 3.180685114013e-01
+ 5.209000000000e-06 3.181294906165e-01
+ 5.210000000000e-06 3.181904698317e-01
+ 5.211000000000e-06 3.182514490469e-01
+ 5.212000000000e-06 3.183124282622e-01
+ 5.213000000000e-06 3.183734074774e-01
+ 5.214000000000e-06 3.184343866926e-01
+ 5.215000000000e-06 3.184953659078e-01
+ 5.216000000000e-06 3.185563451230e-01
+ 5.217000000000e-06 3.186173243382e-01
+ 5.218000000000e-06 3.186783035535e-01
+ 5.219000000000e-06 3.187392827687e-01
+ 5.220000000000e-06 3.188002619839e-01
+ 5.221000000000e-06 3.188612411991e-01
+ 5.222000000000e-06 3.189222204143e-01
+ 5.223000000000e-06 3.189831996295e-01
+ 5.224000000000e-06 3.190441788448e-01
+ 5.225000000000e-06 3.191051580600e-01
+ 5.226000000000e-06 3.191661372752e-01
+ 5.227000000000e-06 3.192271164904e-01
+ 5.228000000000e-06 3.192880957056e-01
+ 5.229000000000e-06 3.193490749208e-01
+ 5.230000000000e-06 3.194100541361e-01
+ 5.231000000000e-06 3.194710333513e-01
+ 5.232000000000e-06 3.195320125665e-01
+ 5.233000000000e-06 3.195929917817e-01
+ 5.234000000000e-06 3.196539709969e-01
+ 5.235000000000e-06 3.197149502121e-01
+ 5.236000000000e-06 3.197759294274e-01
+ 5.237000000000e-06 3.198369086426e-01
+ 5.238000000000e-06 3.198978878578e-01
+ 5.239000000000e-06 3.199588670730e-01
+ 5.240000000000e-06 3.200198462882e-01
+ 5.241000000000e-06 3.200808255034e-01
+ 5.242000000000e-06 3.201418047187e-01
+ 5.243000000000e-06 3.202027839339e-01
+ 5.244000000000e-06 3.202637631491e-01
+ 5.245000000000e-06 3.203247423643e-01
+ 5.246000000000e-06 3.203857215795e-01
+ 5.247000000000e-06 3.204467007947e-01
+ 5.248000000000e-06 3.205076800100e-01
+ 5.249000000000e-06 3.205686592252e-01
+ 5.250000000000e-06 3.206296384404e-01
+ 5.251000000000e-06 3.206906176556e-01
+ 5.252000000000e-06 3.207515968708e-01
+ 5.253000000000e-06 3.208125760860e-01
+ 5.254000000000e-06 3.208735553013e-01
+ 5.255000000000e-06 3.209345345165e-01
+ 5.256000000000e-06 3.209955137317e-01
+ 5.257000000000e-06 3.210564929469e-01
+ 5.258000000000e-06 3.211174721621e-01
+ 5.259000000000e-06 3.211784513773e-01
+ 5.260000000000e-06 3.212394305926e-01
+ 5.261000000000e-06 3.213004098078e-01
+ 5.262000000000e-06 3.213613890230e-01
+ 5.263000000000e-06 3.214223682382e-01
+ 5.264000000000e-06 3.214833474534e-01
+ 5.265000000000e-06 3.215443266686e-01
+ 5.266000000000e-06 3.216053058839e-01
+ 5.267000000000e-06 3.216662850991e-01
+ 5.268000000000e-06 3.217272643143e-01
+ 5.269000000000e-06 3.217882435295e-01
+ 5.270000000000e-06 3.218492227447e-01
+ 5.271000000000e-06 3.219102019599e-01
+ 5.272000000000e-06 3.219711811752e-01
+ 5.273000000000e-06 3.220321603904e-01
+ 5.274000000000e-06 3.220931396056e-01
+ 5.275000000000e-06 3.221541188208e-01
+ 5.276000000000e-06 3.222150980360e-01
+ 5.277000000000e-06 3.222760772512e-01
+ 5.278000000000e-06 3.223370564665e-01
+ 5.279000000000e-06 3.223980356817e-01
+ 5.280000000000e-06 3.224590148969e-01
+ 5.281000000000e-06 3.225199941121e-01
+ 5.282000000000e-06 3.225809733273e-01
+ 5.283000000000e-06 3.226419525425e-01
+ 5.284000000000e-06 3.227029317578e-01
+ 5.285000000000e-06 3.227639109730e-01
+ 5.286000000000e-06 3.228248901882e-01
+ 5.287000000000e-06 3.228858694034e-01
+ 5.288000000000e-06 3.229468486186e-01
+ 5.289000000000e-06 3.230078278338e-01
+ 5.290000000000e-06 3.230688070491e-01
+ 5.291000000000e-06 3.231297862643e-01
+ 5.292000000000e-06 3.231907654795e-01
+ 5.293000000000e-06 3.232517446947e-01
+ 5.294000000000e-06 3.233127239099e-01
+ 5.295000000000e-06 3.233737031251e-01
+ 5.296000000000e-06 3.234346823404e-01
+ 5.297000000000e-06 3.234956615556e-01
+ 5.298000000000e-06 3.235566407708e-01
+ 5.299000000000e-06 3.236176199860e-01
+ 5.300000000000e-06 3.236785992012e-01
+ 5.301000000000e-06 3.237395784164e-01
+ 5.302000000000e-06 3.238005576317e-01
+ 5.303000000000e-06 3.238615368469e-01
+ 5.304000000000e-06 3.239225160621e-01
+ 5.305000000000e-06 3.239834952773e-01
+ 5.306000000000e-06 3.240444744925e-01
+ 5.307000000000e-06 3.241054537077e-01
+ 5.308000000000e-06 3.241664329230e-01
+ 5.309000000000e-06 3.242274121382e-01
+ 5.310000000000e-06 3.242883913534e-01
+ 5.311000000000e-06 3.243493705686e-01
+ 5.312000000000e-06 3.244103497838e-01
+ 5.313000000000e-06 3.244713289990e-01
+ 5.314000000000e-06 3.245323082143e-01
+ 5.315000000000e-06 3.245932874295e-01
+ 5.316000000000e-06 3.246542666447e-01
+ 5.317000000000e-06 3.247152458599e-01
+ 5.318000000000e-06 3.247762250751e-01
+ 5.319000000000e-06 3.248372042903e-01
+ 5.320000000000e-06 3.248981835056e-01
+ 5.321000000000e-06 3.249591627208e-01
+ 5.322000000000e-06 3.250201419360e-01
+ 5.323000000000e-06 3.250811211512e-01
+ 5.324000000000e-06 3.251421003664e-01
+ 5.325000000000e-06 3.252030795816e-01
+ 5.326000000000e-06 3.252640587969e-01
+ 5.327000000000e-06 3.253250380121e-01
+ 5.328000000000e-06 3.253860172273e-01
+ 5.329000000000e-06 3.254469964425e-01
+ 5.330000000000e-06 3.255079756577e-01
+ 5.331000000000e-06 3.255689548729e-01
+ 5.332000000000e-06 3.256299340882e-01
+ 5.333000000000e-06 3.256909133034e-01
+ 5.334000000000e-06 3.257518925186e-01
+ 5.335000000000e-06 3.258128717338e-01
+ 5.336000000000e-06 3.258738509490e-01
+ 5.337000000000e-06 3.259348301642e-01
+ 5.338000000000e-06 3.259958093795e-01
+ 5.339000000000e-06 3.260567885947e-01
+ 5.340000000000e-06 3.261177678099e-01
+ 5.341000000000e-06 3.261787470251e-01
+ 5.342000000000e-06 3.262397262403e-01
+ 5.343000000000e-06 3.263007054555e-01
+ 5.344000000000e-06 3.263616846708e-01
+ 5.345000000000e-06 3.264226638860e-01
+ 5.346000000000e-06 3.264836431012e-01
+ 5.347000000000e-06 3.265446223164e-01
+ 5.348000000000e-06 3.266056015316e-01
+ 5.349000000000e-06 3.266665807468e-01
+ 5.350000000000e-06 3.267275599620e-01
+ 5.351000000000e-06 3.267885391773e-01
+ 5.352000000000e-06 3.268495183925e-01
+ 5.353000000000e-06 3.269104976077e-01
+ 5.354000000000e-06 3.269714768229e-01
+ 5.355000000000e-06 3.270324560381e-01
+ 5.356000000000e-06 3.270934352533e-01
+ 5.357000000000e-06 3.271544144686e-01
+ 5.358000000000e-06 3.272153936838e-01
+ 5.359000000000e-06 3.272763728990e-01
+ 5.360000000000e-06 3.273373521142e-01
+ 5.361000000000e-06 3.273983313294e-01
+ 5.362000000000e-06 3.274593105446e-01
+ 5.363000000000e-06 3.275202897599e-01
+ 5.364000000000e-06 3.275812689751e-01
+ 5.365000000000e-06 3.276422481903e-01
+ 5.366000000000e-06 3.277032274055e-01
+ 5.367000000000e-06 3.277642066207e-01
+ 5.368000000000e-06 3.278251858359e-01
+ 5.369000000000e-06 3.278861650512e-01
+ 5.370000000000e-06 3.279471442664e-01
+ 5.371000000000e-06 3.280081234816e-01
+ 5.372000000000e-06 3.280691026968e-01
+ 5.373000000000e-06 3.281300819120e-01
+ 5.374000000000e-06 3.281910611272e-01
+ 5.375000000000e-06 3.282520403425e-01
+ 5.376000000000e-06 3.283130195577e-01
+ 5.377000000000e-06 3.283739987729e-01
+ 5.378000000000e-06 3.284349779881e-01
+ 5.379000000000e-06 3.284959572033e-01
+ 5.380000000000e-06 3.285569364185e-01
+ 5.381000000000e-06 3.286179156338e-01
+ 5.382000000000e-06 3.286788948490e-01
+ 5.383000000000e-06 3.287398740642e-01
+ 5.384000000000e-06 3.288008532794e-01
+ 5.385000000000e-06 3.288618324946e-01
+ 5.386000000000e-06 3.289228117098e-01
+ 5.387000000000e-06 3.289837909251e-01
+ 5.388000000000e-06 3.290447701403e-01
+ 5.389000000000e-06 3.291057493555e-01
+ 5.390000000000e-06 3.291667285707e-01
+ 5.391000000000e-06 3.292277077859e-01
+ 5.392000000000e-06 3.292886870011e-01
+ 5.393000000000e-06 3.293496662164e-01
+ 5.394000000000e-06 3.294106454316e-01
+ 5.395000000000e-06 3.294716246468e-01
+ 5.396000000000e-06 3.295326038620e-01
+ 5.397000000000e-06 3.295935830772e-01
+ 5.398000000000e-06 3.296545622924e-01
+ 5.399000000000e-06 3.297155415077e-01
+ 5.400000000000e-06 3.297765207229e-01
+ 5.401000000000e-06 3.298374999381e-01
+ 5.402000000000e-06 3.298984791533e-01
+ 5.403000000000e-06 3.299594583685e-01
+ 5.404000000000e-06 3.300204375837e-01
+ 5.405000000000e-06 3.300814167990e-01
+ 5.406000000000e-06 3.301423960142e-01
+ 5.407000000000e-06 3.302033752294e-01
+ 5.408000000000e-06 3.302643544446e-01
+ 5.409000000000e-06 3.303253336598e-01
+ 5.410000000000e-06 3.303863128750e-01
+ 5.411000000000e-06 3.304472920903e-01
+ 5.412000000000e-06 3.305082713055e-01
+ 5.413000000000e-06 3.305692505207e-01
+ 5.414000000000e-06 3.306302297359e-01
+ 5.415000000000e-06 3.306912089511e-01
+ 5.416000000000e-06 3.307521881663e-01
+ 5.417000000000e-06 3.308131673816e-01
+ 5.418000000000e-06 3.308741465968e-01
+ 5.419000000000e-06 3.309351258120e-01
+ 5.420000000000e-06 3.309961050272e-01
+ 5.421000000000e-06 3.310570842424e-01
+ 5.422000000000e-06 3.311180634576e-01
+ 5.423000000000e-06 3.311790426729e-01
+ 5.424000000000e-06 3.312400218881e-01
+ 5.425000000000e-06 3.313010011033e-01
+ 5.426000000000e-06 3.313619803185e-01
+ 5.427000000000e-06 3.314229595337e-01
+ 5.428000000000e-06 3.314839387489e-01
+ 5.429000000000e-06 3.315449179642e-01
+ 5.430000000000e-06 3.316058971794e-01
+ 5.431000000000e-06 3.316668763946e-01
+ 5.432000000000e-06 3.317278556098e-01
+ 5.433000000000e-06 3.317888348250e-01
+ 5.434000000000e-06 3.318498140402e-01
+ 5.435000000000e-06 3.319107932555e-01
+ 5.436000000000e-06 3.319717724707e-01
+ 5.437000000000e-06 3.320327516859e-01
+ 5.438000000000e-06 3.320937309011e-01
+ 5.439000000000e-06 3.321547101163e-01
+ 5.440000000000e-06 3.322156893315e-01
+ 5.441000000000e-06 3.322766685468e-01
+ 5.442000000000e-06 3.323376477620e-01
+ 5.443000000000e-06 3.323986269772e-01
+ 5.444000000000e-06 3.324596061924e-01
+ 5.445000000000e-06 3.325205854076e-01
+ 5.446000000000e-06 3.325815646228e-01
+ 5.447000000000e-06 3.326425438381e-01
+ 5.448000000000e-06 3.327035230533e-01
+ 5.449000000000e-06 3.327645022685e-01
+ 5.450000000000e-06 3.328254814837e-01
+ 5.451000000000e-06 3.328864606989e-01
+ 5.452000000000e-06 3.329474399141e-01
+ 5.453000000000e-06 3.330084191294e-01
+ 5.454000000000e-06 3.330693983446e-01
+ 5.455000000000e-06 3.331303775598e-01
+ 5.456000000000e-06 3.331913567750e-01
+ 5.457000000000e-06 3.332523359902e-01
+ 5.458000000000e-06 3.333133152054e-01
+ 5.459000000000e-06 3.333742944207e-01
+ 5.460000000000e-06 3.334352736359e-01
+ 5.461000000000e-06 3.334962528511e-01
+ 5.462000000000e-06 3.335572320663e-01
+ 5.463000000000e-06 3.336182112815e-01
+ 5.464000000000e-06 3.336791904967e-01
+ 5.465000000000e-06 3.337401697120e-01
+ 5.466000000000e-06 3.338011489272e-01
+ 5.467000000000e-06 3.338621281424e-01
+ 5.468000000000e-06 3.339231073576e-01
+ 5.469000000000e-06 3.339840865728e-01
+ 5.470000000000e-06 3.340450657880e-01
+ 5.471000000000e-06 3.341060450033e-01
+ 5.472000000000e-06 3.341670242185e-01
+ 5.473000000000e-06 3.342280034337e-01
+ 5.474000000000e-06 3.342889826489e-01
+ 5.475000000000e-06 3.343499618641e-01
+ 5.476000000000e-06 3.344109410793e-01
+ 5.477000000000e-06 3.344719202946e-01
+ 5.478000000000e-06 3.345328995098e-01
+ 5.479000000000e-06 3.345938787250e-01
+ 5.480000000000e-06 3.346548579402e-01
+ 5.481000000000e-06 3.347158371554e-01
+ 5.482000000000e-06 3.347768163706e-01
+ 5.483000000000e-06 3.348377955859e-01
+ 5.484000000000e-06 3.348987748011e-01
+ 5.485000000000e-06 3.349597540163e-01
+ 5.486000000000e-06 3.350207332315e-01
+ 5.487000000000e-06 3.350817124467e-01
+ 5.488000000000e-06 3.351426916619e-01
+ 5.489000000000e-06 3.352036708772e-01
+ 5.490000000000e-06 3.352646500924e-01
+ 5.491000000000e-06 3.353256293076e-01
+ 5.492000000000e-06 3.353866085228e-01
+ 5.493000000000e-06 3.354475877380e-01
+ 5.494000000000e-06 3.355085669532e-01
+ 5.495000000000e-06 3.355695461685e-01
+ 5.496000000000e-06 3.356305253837e-01
+ 5.497000000000e-06 3.356915045989e-01
+ 5.498000000000e-06 3.357524838141e-01
+ 5.499000000000e-06 3.358134630293e-01
+ 5.500000000000e-06 3.358744422445e-01
+ 5.501000000000e-06 3.359354214598e-01
+ 5.502000000000e-06 3.359964006750e-01
+ 5.503000000000e-06 3.360573798902e-01
+ 5.504000000000e-06 3.361183591054e-01
+ 5.505000000000e-06 3.361793383206e-01
+ 5.506000000000e-06 3.362403175358e-01
+ 5.507000000000e-06 3.363012967511e-01
+ 5.508000000000e-06 3.363622759663e-01
+ 5.509000000000e-06 3.364232551815e-01
+ 5.510000000000e-06 3.364842343967e-01
+ 5.511000000000e-06 3.365452136119e-01
+ 5.512000000000e-06 3.366061928271e-01
+ 5.513000000000e-06 3.366671720424e-01
+ 5.514000000000e-06 3.367281512576e-01
+ 5.515000000000e-06 3.367891304728e-01
+ 5.516000000000e-06 3.368501096880e-01
+ 5.517000000000e-06 3.369110889032e-01
+ 5.518000000000e-06 3.369720681184e-01
+ 5.519000000000e-06 3.370330473337e-01
+ 5.520000000000e-06 3.370940265489e-01
+ 5.521000000000e-06 3.371550057641e-01
+ 5.522000000000e-06 3.372159849793e-01
+ 5.523000000000e-06 3.372769641945e-01
+ 5.524000000000e-06 3.373379434097e-01
+ 5.525000000000e-06 3.373989226250e-01
+ 5.526000000000e-06 3.374599018402e-01
+ 5.527000000000e-06 3.375208810554e-01
+ 5.528000000000e-06 3.375818602706e-01
+ 5.529000000000e-06 3.376428394858e-01
+ 5.530000000000e-06 3.377038187010e-01
+ 5.531000000000e-06 3.377647979163e-01
+ 5.532000000000e-06 3.378257771315e-01
+ 5.533000000000e-06 3.378867563467e-01
+ 5.534000000000e-06 3.379477355619e-01
+ 5.535000000000e-06 3.380087147771e-01
+ 5.536000000000e-06 3.380696939923e-01
+ 5.537000000000e-06 3.381306732076e-01
+ 5.538000000000e-06 3.381916524228e-01
+ 5.539000000000e-06 3.382526316380e-01
+ 5.540000000000e-06 3.383136108532e-01
+ 5.541000000000e-06 3.383745900684e-01
+ 5.542000000000e-06 3.384355692836e-01
+ 5.543000000000e-06 3.384965484989e-01
+ 5.544000000000e-06 3.385575277141e-01
+ 5.545000000000e-06 3.386185069293e-01
+ 5.546000000000e-06 3.386794861445e-01
+ 5.547000000000e-06 3.387404653597e-01
+ 5.548000000000e-06 3.388014445749e-01
+ 5.549000000000e-06 3.388624237902e-01
+ 5.550000000000e-06 3.389234030054e-01
+ 5.551000000000e-06 3.389843822206e-01
+ 5.552000000000e-06 3.390453614358e-01
+ 5.553000000000e-06 3.391063406510e-01
+ 5.554000000000e-06 3.391673198662e-01
+ 5.555000000000e-06 3.392282990815e-01
+ 5.556000000000e-06 3.392892782967e-01
+ 5.557000000000e-06 3.393502575119e-01
+ 5.558000000000e-06 3.394112367271e-01
+ 5.559000000000e-06 3.394722159423e-01
+ 5.560000000000e-06 3.395331951575e-01
+ 5.561000000000e-06 3.395941743728e-01
+ 5.562000000000e-06 3.396551535880e-01
+ 5.563000000000e-06 3.397161328032e-01
+ 5.564000000000e-06 3.397771120184e-01
+ 5.565000000000e-06 3.398380912336e-01
+ 5.566000000000e-06 3.398990704488e-01
+ 5.567000000000e-06 3.399600496641e-01
+ 5.568000000000e-06 3.400210288793e-01
+ 5.569000000000e-06 3.400820080945e-01
+ 5.570000000000e-06 3.401429873097e-01
+ 5.571000000000e-06 3.402039665249e-01
+ 5.572000000000e-06 3.402649457401e-01
+ 5.573000000000e-06 3.403259249554e-01
+ 5.574000000000e-06 3.403869041706e-01
+ 5.575000000000e-06 3.404478833858e-01
+ 5.576000000000e-06 3.405088626010e-01
+ 5.577000000000e-06 3.405698418162e-01
+ 5.578000000000e-06 3.406308210314e-01
+ 5.579000000000e-06 3.406918002466e-01
+ 5.580000000000e-06 3.407527794619e-01
+ 5.581000000000e-06 3.408137586771e-01
+ 5.582000000000e-06 3.408747378923e-01
+ 5.583000000000e-06 3.409357171075e-01
+ 5.584000000000e-06 3.409966963227e-01
+ 5.585000000000e-06 3.410576755379e-01
+ 5.586000000000e-06 3.411186547532e-01
+ 5.587000000000e-06 3.411796339684e-01
+ 5.588000000000e-06 3.412406131836e-01
+ 5.589000000000e-06 3.413015923988e-01
+ 5.590000000000e-06 3.413625716140e-01
+ 5.591000000000e-06 3.414235508292e-01
+ 5.592000000000e-06 3.414845300445e-01
+ 5.593000000000e-06 3.415455092597e-01
+ 5.594000000000e-06 3.416064884749e-01
+ 5.595000000000e-06 3.416674676901e-01
+ 5.596000000000e-06 3.417284469053e-01
+ 5.597000000000e-06 3.417894261205e-01
+ 5.598000000000e-06 3.418504053358e-01
+ 5.599000000000e-06 3.419113845510e-01
+ 5.600000000000e-06 3.419723637662e-01
+ 5.601000000000e-06 3.420333429814e-01
+ 5.602000000000e-06 3.420943221966e-01
+ 5.603000000000e-06 3.421553014118e-01
+ 5.604000000000e-06 3.422162806271e-01
+ 5.605000000000e-06 3.422772598423e-01
+ 5.606000000000e-06 3.423382390575e-01
+ 5.607000000000e-06 3.423992182727e-01
+ 5.608000000000e-06 3.424601974879e-01
+ 5.609000000000e-06 3.425211767031e-01
+ 5.610000000000e-06 3.425821559184e-01
+ 5.611000000000e-06 3.426431351336e-01
+ 5.612000000000e-06 3.427041143488e-01
+ 5.613000000000e-06 3.427650935640e-01
+ 5.614000000000e-06 3.428260727792e-01
+ 5.615000000000e-06 3.428870519944e-01
+ 5.616000000000e-06 3.429480312097e-01
+ 5.617000000000e-06 3.430090104249e-01
+ 5.618000000000e-06 3.430699896401e-01
+ 5.619000000000e-06 3.431309688553e-01
+ 5.620000000000e-06 3.431919480705e-01
+ 5.621000000000e-06 3.432529272857e-01
+ 5.622000000000e-06 3.433139065010e-01
+ 5.623000000000e-06 3.433748857162e-01
+ 5.624000000000e-06 3.434358649314e-01
+ 5.625000000000e-06 3.434968441466e-01
+ 5.626000000000e-06 3.435578233618e-01
+ 5.627000000000e-06 3.436188025770e-01
+ 5.628000000000e-06 3.436797817923e-01
+ 5.629000000000e-06 3.437407610075e-01
+ 5.630000000000e-06 3.438017402227e-01
+ 5.631000000000e-06 3.438627194379e-01
+ 5.632000000000e-06 3.439236986531e-01
+ 5.633000000000e-06 3.439846778683e-01
+ 5.634000000000e-06 3.440456570836e-01
+ 5.635000000000e-06 3.441066362988e-01
+ 5.636000000000e-06 3.441676155140e-01
+ 5.637000000000e-06 3.442285947292e-01
+ 5.638000000000e-06 3.442895739444e-01
+ 5.639000000000e-06 3.443505531596e-01
+ 5.640000000000e-06 3.444115323749e-01
+ 5.641000000000e-06 3.444725115901e-01
+ 5.642000000000e-06 3.445334908053e-01
+ 5.643000000000e-06 3.445944700205e-01
+ 5.644000000000e-06 3.446554492357e-01
+ 5.645000000000e-06 3.447164284509e-01
+ 5.646000000000e-06 3.447774076662e-01
+ 5.647000000000e-06 3.448383868814e-01
+ 5.648000000000e-06 3.448993660966e-01
+ 5.649000000000e-06 3.449603453118e-01
+ 5.650000000000e-06 3.450213245270e-01
+ 5.651000000000e-06 3.450823037422e-01
+ 5.652000000000e-06 3.451432829575e-01
+ 5.653000000000e-06 3.452042621727e-01
+ 5.654000000000e-06 3.452652413879e-01
+ 5.655000000000e-06 3.453262206031e-01
+ 5.656000000000e-06 3.453871998183e-01
+ 5.657000000000e-06 3.454481790335e-01
+ 5.658000000000e-06 3.455091582488e-01
+ 5.659000000000e-06 3.455701374640e-01
+ 5.660000000000e-06 3.456311166792e-01
+ 5.661000000000e-06 3.456920958944e-01
+ 5.662000000000e-06 3.457530751096e-01
+ 5.663000000000e-06 3.458140543248e-01
+ 5.664000000000e-06 3.458750335401e-01
+ 5.665000000000e-06 3.459360127553e-01
+ 5.666000000000e-06 3.459969919705e-01
+ 5.667000000000e-06 3.460579711857e-01
+ 5.668000000000e-06 3.461189504009e-01
+ 5.669000000000e-06 3.461799296161e-01
+ 5.670000000000e-06 3.462409088314e-01
+ 5.671000000000e-06 3.463018880466e-01
+ 5.672000000000e-06 3.463628672618e-01
+ 5.673000000000e-06 3.464238464770e-01
+ 5.674000000000e-06 3.464848256922e-01
+ 5.675000000000e-06 3.465458049074e-01
+ 5.676000000000e-06 3.466067841227e-01
+ 5.677000000000e-06 3.466677633379e-01
+ 5.678000000000e-06 3.467287425531e-01
+ 5.679000000000e-06 3.467897217683e-01
+ 5.680000000000e-06 3.468507009835e-01
+ 5.681000000000e-06 3.469116801987e-01
+ 5.682000000000e-06 3.469726594140e-01
+ 5.683000000000e-06 3.470336386292e-01
+ 5.684000000000e-06 3.470946178444e-01
+ 5.685000000000e-06 3.471555970596e-01
+ 5.686000000000e-06 3.472165762748e-01
+ 5.687000000000e-06 3.472775554900e-01
+ 5.688000000000e-06 3.473385347053e-01
+ 5.689000000000e-06 3.473995139205e-01
+ 5.690000000000e-06 3.474604931357e-01
+ 5.691000000000e-06 3.475214723509e-01
+ 5.692000000000e-06 3.475824515661e-01
+ 5.693000000000e-06 3.476434307813e-01
+ 5.694000000000e-06 3.477044099966e-01
+ 5.695000000000e-06 3.477653892118e-01
+ 5.696000000000e-06 3.478263684270e-01
+ 5.697000000000e-06 3.478873476422e-01
+ 5.698000000000e-06 3.479483268574e-01
+ 5.699000000000e-06 3.480093060726e-01
+ 5.700000000000e-06 3.480702852879e-01
+ 5.701000000000e-06 3.481312645031e-01
+ 5.702000000000e-06 3.481922437183e-01
+ 5.703000000000e-06 3.482532229335e-01
+ 5.704000000000e-06 3.483142021487e-01
+ 5.705000000000e-06 3.483751813639e-01
+ 5.706000000000e-06 3.484361605792e-01
+ 5.707000000000e-06 3.484971397944e-01
+ 5.708000000000e-06 3.485581190096e-01
+ 5.709000000000e-06 3.486190982248e-01
+ 5.710000000000e-06 3.486800774400e-01
+ 5.711000000000e-06 3.487410566552e-01
+ 5.712000000000e-06 3.488020358705e-01
+ 5.713000000000e-06 3.488630150857e-01
+ 5.714000000000e-06 3.489239943009e-01
+ 5.715000000000e-06 3.489849735161e-01
+ 5.716000000000e-06 3.490459527313e-01
+ 5.717000000000e-06 3.491069319465e-01
+ 5.718000000000e-06 3.491679111618e-01
+ 5.719000000000e-06 3.492288903770e-01
+ 5.720000000000e-06 3.492898695922e-01
+ 5.721000000000e-06 3.493508488074e-01
+ 5.722000000000e-06 3.494118280226e-01
+ 5.723000000000e-06 3.494728072378e-01
+ 5.724000000000e-06 3.495337864531e-01
+ 5.725000000000e-06 3.495947656683e-01
+ 5.726000000000e-06 3.496557448835e-01
+ 5.727000000000e-06 3.497167240987e-01
+ 5.728000000000e-06 3.497777033139e-01
+ 5.729000000000e-06 3.498386825291e-01
+ 5.730000000000e-06 3.498996617444e-01
+ 5.731000000000e-06 3.499606409596e-01
+ 5.732000000000e-06 3.500216201748e-01
+ 5.733000000000e-06 3.500825993900e-01
+ 5.734000000000e-06 3.501435786052e-01
+ 5.735000000000e-06 3.502045578204e-01
+ 5.736000000000e-06 3.502655370357e-01
+ 5.737000000000e-06 3.503265162509e-01
+ 5.738000000000e-06 3.503874954661e-01
+ 5.739000000000e-06 3.504484746813e-01
+ 5.740000000000e-06 3.505094538965e-01
+ 5.741000000000e-06 3.505704331117e-01
+ 5.742000000000e-06 3.506314123270e-01
+ 5.743000000000e-06 3.506923915422e-01
+ 5.744000000000e-06 3.507533707574e-01
+ 5.745000000000e-06 3.508143499726e-01
+ 5.746000000000e-06 3.508753291878e-01
+ 5.747000000000e-06 3.509363084030e-01
+ 5.748000000000e-06 3.509972876183e-01
+ 5.749000000000e-06 3.510582668335e-01
+ 5.750000000000e-06 3.511192460487e-01
+ 5.751000000000e-06 3.511802252639e-01
+ 5.752000000000e-06 3.512412044791e-01
+ 5.753000000000e-06 3.513021836943e-01
+ 5.754000000000e-06 3.513631629096e-01
+ 5.755000000000e-06 3.514241421248e-01
+ 5.756000000000e-06 3.514851213400e-01
+ 5.757000000000e-06 3.515461005552e-01
+ 5.758000000000e-06 3.516070797704e-01
+ 5.759000000000e-06 3.516680589856e-01
+ 5.760000000000e-06 3.517290382009e-01
+ 5.761000000000e-06 3.517900174161e-01
+ 5.762000000000e-06 3.518509966313e-01
+ 5.763000000000e-06 3.519119758465e-01
+ 5.764000000000e-06 3.519729550617e-01
+ 5.765000000000e-06 3.520339342769e-01
+ 5.766000000000e-06 3.520949134922e-01
+ 5.767000000000e-06 3.521558927074e-01
+ 5.768000000000e-06 3.522168719226e-01
+ 5.769000000000e-06 3.522778511378e-01
+ 5.770000000000e-06 3.523388303530e-01
+ 5.771000000000e-06 3.523998095682e-01
+ 5.772000000000e-06 3.524607887835e-01
+ 5.773000000000e-06 3.525217679987e-01
+ 5.774000000000e-06 3.525827472139e-01
+ 5.775000000000e-06 3.526437264291e-01
+ 5.776000000000e-06 3.527047056443e-01
+ 5.777000000000e-06 3.527656848595e-01
+ 5.778000000000e-06 3.528266640748e-01
+ 5.779000000000e-06 3.528876432900e-01
+ 5.780000000000e-06 3.529486225052e-01
+ 5.781000000000e-06 3.530096017204e-01
+ 5.782000000000e-06 3.530705809356e-01
+ 5.783000000000e-06 3.531315601508e-01
+ 5.784000000000e-06 3.531925393661e-01
+ 5.785000000000e-06 3.532535185813e-01
+ 5.786000000000e-06 3.533144977965e-01
+ 5.787000000000e-06 3.533754770117e-01
+ 5.788000000000e-06 3.534364562269e-01
+ 5.789000000000e-06 3.534974354421e-01
+ 5.790000000000e-06 3.535584146574e-01
+ 5.791000000000e-06 3.536193938726e-01
+ 5.792000000000e-06 3.536803730878e-01
+ 5.793000000000e-06 3.537413523030e-01
+ 5.794000000000e-06 3.538023315182e-01
+ 5.795000000000e-06 3.538633107334e-01
+ 5.796000000000e-06 3.539242899487e-01
+ 5.797000000000e-06 3.539852691639e-01
+ 5.798000000000e-06 3.540462483791e-01
+ 5.799000000000e-06 3.541072275943e-01
+ 5.800000000000e-06 3.541682068095e-01
+ 5.801000000000e-06 3.542291860247e-01
+ 5.802000000000e-06 3.542901652399e-01
+ 5.803000000000e-06 3.543511444552e-01
+ 5.804000000000e-06 3.544121236704e-01
+ 5.805000000000e-06 3.544731028856e-01
+ 5.806000000000e-06 3.545340821008e-01
+ 5.807000000000e-06 3.545950613160e-01
+ 5.808000000000e-06 3.546560405312e-01
+ 5.809000000000e-06 3.547170197465e-01
+ 5.810000000000e-06 3.547779989617e-01
+ 5.811000000000e-06 3.548389781769e-01
+ 5.812000000000e-06 3.548999573921e-01
+ 5.813000000000e-06 3.549609366073e-01
+ 5.814000000000e-06 3.550219158225e-01
+ 5.815000000000e-06 3.550828950378e-01
+ 5.816000000000e-06 3.551438742530e-01
+ 5.817000000000e-06 3.552048534682e-01
+ 5.818000000000e-06 3.552658326834e-01
+ 5.819000000000e-06 3.553268118986e-01
+ 5.820000000000e-06 3.553877911138e-01
+ 5.821000000000e-06 3.554487703291e-01
+ 5.822000000000e-06 3.555097495443e-01
+ 5.823000000000e-06 3.555707287595e-01
+ 5.824000000000e-06 3.556317079747e-01
+ 5.825000000000e-06 3.556926871899e-01
+ 5.826000000000e-06 3.557536664051e-01
+ 5.827000000000e-06 3.558146456204e-01
+ 5.828000000000e-06 3.558756248356e-01
+ 5.829000000000e-06 3.559366040508e-01
+ 5.830000000000e-06 3.559975832660e-01
+ 5.831000000000e-06 3.560585624812e-01
+ 5.832000000000e-06 3.561195416964e-01
+ 5.833000000000e-06 3.561805209117e-01
+ 5.834000000000e-06 3.562415001269e-01
+ 5.835000000000e-06 3.563024793421e-01
+ 5.836000000000e-06 3.563634585573e-01
+ 5.837000000000e-06 3.564244377725e-01
+ 5.838000000000e-06 3.564854169877e-01
+ 5.839000000000e-06 3.565463962030e-01
+ 5.840000000000e-06 3.566073754182e-01
+ 5.841000000000e-06 3.566683546334e-01
+ 5.842000000000e-06 3.567293338486e-01
+ 5.843000000000e-06 3.567903130638e-01
+ 5.844000000000e-06 3.568512922790e-01
+ 5.845000000000e-06 3.569122714943e-01
+ 5.846000000000e-06 3.569732507095e-01
+ 5.847000000000e-06 3.570342299247e-01
+ 5.848000000000e-06 3.570952091399e-01
+ 5.849000000000e-06 3.571561883551e-01
+ 5.850000000000e-06 3.572171675703e-01
+ 5.851000000000e-06 3.572781467856e-01
+ 5.852000000000e-06 3.573391260008e-01
+ 5.853000000000e-06 3.574001052160e-01
+ 5.854000000000e-06 3.574610844312e-01
+ 5.855000000000e-06 3.575220636464e-01
+ 5.856000000000e-06 3.575830428616e-01
+ 5.857000000000e-06 3.576440220769e-01
+ 5.858000000000e-06 3.577050012921e-01
+ 5.859000000000e-06 3.577659805073e-01
+ 5.860000000000e-06 3.578269597225e-01
+ 5.861000000000e-06 3.578879389377e-01
+ 5.862000000000e-06 3.579489181529e-01
+ 5.863000000000e-06 3.580098973682e-01
+ 5.864000000000e-06 3.580708765834e-01
+ 5.865000000000e-06 3.581318557986e-01
+ 5.866000000000e-06 3.581928350138e-01
+ 5.867000000000e-06 3.582538142290e-01
+ 5.868000000000e-06 3.583147934442e-01
+ 5.869000000000e-06 3.583757726595e-01
+ 5.870000000000e-06 3.584367518747e-01
+ 5.871000000000e-06 3.584977310899e-01
+ 5.872000000000e-06 3.585587103051e-01
+ 5.873000000000e-06 3.586196895203e-01
+ 5.874000000000e-06 3.586806687355e-01
+ 5.875000000000e-06 3.587416479508e-01
+ 5.876000000000e-06 3.588026271660e-01
+ 5.877000000000e-06 3.588636063812e-01
+ 5.878000000000e-06 3.589245855964e-01
+ 5.879000000000e-06 3.589855648116e-01
+ 5.880000000000e-06 3.590465440268e-01
+ 5.881000000000e-06 3.591075232421e-01
+ 5.882000000000e-06 3.591685024573e-01
+ 5.883000000000e-06 3.592294816725e-01
+ 5.884000000000e-06 3.592904608877e-01
+ 5.885000000000e-06 3.593514401029e-01
+ 5.886000000000e-06 3.594124193181e-01
+ 5.887000000000e-06 3.594733985334e-01
+ 5.888000000000e-06 3.595343777486e-01
+ 5.889000000000e-06 3.595953569638e-01
+ 5.890000000000e-06 3.596563361790e-01
+ 5.891000000000e-06 3.597173153942e-01
+ 5.892000000000e-06 3.597782946094e-01
+ 5.893000000000e-06 3.598392738247e-01
+ 5.894000000000e-06 3.599002530399e-01
+ 5.895000000000e-06 3.599612322551e-01
+ 5.896000000000e-06 3.600222114703e-01
+ 5.897000000000e-06 3.600831906855e-01
+ 5.898000000000e-06 3.601441699007e-01
+ 5.899000000000e-06 3.602051491160e-01
+ 5.900000000000e-06 3.602661283312e-01
+ 5.901000000000e-06 3.603271075464e-01
+ 5.902000000000e-06 3.603880867616e-01
+ 5.903000000000e-06 3.604490659768e-01
+ 5.904000000000e-06 3.605100451920e-01
+ 5.905000000000e-06 3.605710244073e-01
+ 5.906000000000e-06 3.606320036225e-01
+ 5.907000000000e-06 3.606929828377e-01
+ 5.908000000000e-06 3.607539620529e-01
+ 5.909000000000e-06 3.608149412681e-01
+ 5.910000000000e-06 3.608759204833e-01
+ 5.911000000000e-06 3.609368996986e-01
+ 5.912000000000e-06 3.609978789138e-01
+ 5.913000000000e-06 3.610588581290e-01
+ 5.914000000000e-06 3.611198373442e-01
+ 5.915000000000e-06 3.611808165594e-01
+ 5.916000000000e-06 3.612417957746e-01
+ 5.917000000000e-06 3.613027749899e-01
+ 5.918000000000e-06 3.613637542051e-01
+ 5.919000000000e-06 3.614247334203e-01
+ 5.920000000000e-06 3.614857126355e-01
+ 5.921000000000e-06 3.615466918507e-01
+ 5.922000000000e-06 3.616076710659e-01
+ 5.923000000000e-06 3.616686502812e-01
+ 5.924000000000e-06 3.617296294964e-01
+ 5.925000000000e-06 3.617906087116e-01
+ 5.926000000000e-06 3.618515879268e-01
+ 5.927000000000e-06 3.619125671420e-01
+ 5.928000000000e-06 3.619735463572e-01
+ 5.929000000000e-06 3.620345255725e-01
+ 5.930000000000e-06 3.620955047877e-01
+ 5.931000000000e-06 3.621564840029e-01
+ 5.932000000000e-06 3.622174632181e-01
+ 5.933000000000e-06 3.622784424333e-01
+ 5.934000000000e-06 3.623394216485e-01
+ 5.935000000000e-06 3.624004008638e-01
+ 5.936000000000e-06 3.624613800790e-01
+ 5.937000000000e-06 3.625223592942e-01
+ 5.938000000000e-06 3.625833385094e-01
+ 5.939000000000e-06 3.626443177246e-01
+ 5.940000000000e-06 3.627052969398e-01
+ 5.941000000000e-06 3.627662761551e-01
+ 5.942000000000e-06 3.628272553703e-01
+ 5.943000000000e-06 3.628882345855e-01
+ 5.944000000000e-06 3.629492138007e-01
+ 5.945000000000e-06 3.630101930159e-01
+ 5.946000000000e-06 3.630711722311e-01
+ 5.947000000000e-06 3.631321514464e-01
+ 5.948000000000e-06 3.631931306616e-01
+ 5.949000000000e-06 3.632541098768e-01
+ 5.950000000000e-06 3.633150890920e-01
+ 5.951000000000e-06 3.633760683072e-01
+ 5.952000000000e-06 3.634370475224e-01
+ 5.953000000000e-06 3.634980267377e-01
+ 5.954000000000e-06 3.635590059529e-01
+ 5.955000000000e-06 3.636199851681e-01
+ 5.956000000000e-06 3.636809643833e-01
+ 5.957000000000e-06 3.637419435985e-01
+ 5.958000000000e-06 3.638029228137e-01
+ 5.959000000000e-06 3.638639020290e-01
+ 5.960000000000e-06 3.639248812442e-01
+ 5.961000000000e-06 3.639858604594e-01
+ 5.962000000000e-06 3.640468396746e-01
+ 5.963000000000e-06 3.641078188898e-01
+ 5.964000000000e-06 3.641687981050e-01
+ 5.965000000000e-06 3.642297773203e-01
+ 5.966000000000e-06 3.642907565355e-01
+ 5.967000000000e-06 3.643517357507e-01
+ 5.968000000000e-06 3.644127149659e-01
+ 5.969000000000e-06 3.644736941811e-01
+ 5.970000000000e-06 3.645346733963e-01
+ 5.971000000000e-06 3.645956526116e-01
+ 5.972000000000e-06 3.646566318268e-01
+ 5.973000000000e-06 3.647176110420e-01
+ 5.974000000000e-06 3.647785902572e-01
+ 5.975000000000e-06 3.648395694724e-01
+ 5.976000000000e-06 3.649005486876e-01
+ 5.977000000000e-06 3.649615279029e-01
+ 5.978000000000e-06 3.650225071181e-01
+ 5.979000000000e-06 3.650834863333e-01
+ 5.980000000000e-06 3.651444655485e-01
+ 5.981000000000e-06 3.652054447637e-01
+ 5.982000000000e-06 3.652664239789e-01
+ 5.983000000000e-06 3.653274031942e-01
+ 5.984000000000e-06 3.653883824094e-01
+ 5.985000000000e-06 3.654493616246e-01
+ 5.986000000000e-06 3.655103408398e-01
+ 5.987000000000e-06 3.655713200550e-01
+ 5.988000000000e-06 3.656322992702e-01
+ 5.989000000000e-06 3.656932784855e-01
+ 5.990000000000e-06 3.657542577007e-01
+ 5.991000000000e-06 3.658152369159e-01
+ 5.992000000000e-06 3.658762161311e-01
+ 5.993000000000e-06 3.659371953463e-01
+ 5.994000000000e-06 3.659981745615e-01
+ 5.995000000000e-06 3.660591537768e-01
+ 5.996000000000e-06 3.661201329920e-01
+ 5.997000000000e-06 3.661811122072e-01
+ 5.998000000000e-06 3.662420914224e-01
+ 5.999000000000e-06 3.663030706376e-01
+ 6.000000000000e-06 3.663640498528e-01
+ 6.001000000000e-06 3.664250290681e-01
+ 6.002000000000e-06 3.664860082833e-01
+ 6.003000000000e-06 3.665469874985e-01
+ 6.004000000000e-06 3.666079667137e-01
+ 6.005000000000e-06 3.666689459289e-01
+ 6.006000000000e-06 3.667299251441e-01
+ 6.007000000000e-06 3.667909043594e-01
+ 6.008000000000e-06 3.668518835746e-01
+ 6.009000000000e-06 3.669128627898e-01
+ 6.010000000000e-06 3.669738420050e-01
+ 6.011000000000e-06 3.670348212202e-01
+ 6.012000000000e-06 3.670958004354e-01
+ 6.013000000000e-06 3.671567796507e-01
+ 6.014000000000e-06 3.672177588659e-01
+ 6.015000000000e-06 3.672787380811e-01
+ 6.016000000000e-06 3.673397172963e-01
+ 6.017000000000e-06 3.674006965115e-01
+ 6.018000000000e-06 3.674616757267e-01
+ 6.019000000000e-06 3.675226549420e-01
+ 6.020000000000e-06 3.675836341572e-01
+ 6.021000000000e-06 3.676446133724e-01
+ 6.022000000000e-06 3.677055925876e-01
+ 6.023000000000e-06 3.677665718028e-01
+ 6.024000000000e-06 3.678275510180e-01
+ 6.025000000000e-06 3.678885302333e-01
+ 6.026000000000e-06 3.679495094485e-01
+ 6.027000000000e-06 3.680104886637e-01
+ 6.028000000000e-06 3.680714678789e-01
+ 6.029000000000e-06 3.681324470941e-01
+ 6.030000000000e-06 3.681934263093e-01
+ 6.031000000000e-06 3.682544055245e-01
+ 6.032000000000e-06 3.683153847398e-01
+ 6.033000000000e-06 3.683763639550e-01
+ 6.034000000000e-06 3.684373431702e-01
+ 6.035000000000e-06 3.684983223854e-01
+ 6.036000000000e-06 3.685593016006e-01
+ 6.037000000000e-06 3.686202808158e-01
+ 6.038000000000e-06 3.686812600311e-01
+ 6.039000000000e-06 3.687422392463e-01
+ 6.040000000000e-06 3.688032184615e-01
+ 6.041000000000e-06 3.688641976767e-01
+ 6.042000000000e-06 3.689251768919e-01
+ 6.043000000000e-06 3.689861561071e-01
+ 6.044000000000e-06 3.690471353224e-01
+ 6.045000000000e-06 3.691081145376e-01
+ 6.046000000000e-06 3.691690937528e-01
+ 6.047000000000e-06 3.692300729680e-01
+ 6.048000000000e-06 3.692910521832e-01
+ 6.049000000000e-06 3.693520313984e-01
+ 6.050000000000e-06 3.694130106137e-01
+ 6.051000000000e-06 3.694739898289e-01
+ 6.052000000000e-06 3.695349690441e-01
+ 6.053000000000e-06 3.695959482593e-01
+ 6.054000000000e-06 3.696569274745e-01
+ 6.055000000000e-06 3.697179066897e-01
+ 6.056000000000e-06 3.697788859050e-01
+ 6.057000000000e-06 3.698398651202e-01
+ 6.058000000000e-06 3.699008443354e-01
+ 6.059000000000e-06 3.699618235506e-01
+ 6.060000000000e-06 3.700228027658e-01
+ 6.061000000000e-06 3.700837819810e-01
+ 6.062000000000e-06 3.701447611963e-01
+ 6.063000000000e-06 3.702057404115e-01
+ 6.064000000000e-06 3.702667196267e-01
+ 6.065000000000e-06 3.703276988419e-01
+ 6.066000000000e-06 3.703886780571e-01
+ 6.067000000000e-06 3.704496572723e-01
+ 6.068000000000e-06 3.705106364876e-01
+ 6.069000000000e-06 3.705716157028e-01
+ 6.070000000000e-06 3.706325949180e-01
+ 6.071000000000e-06 3.706935741332e-01
+ 6.072000000000e-06 3.707545533484e-01
+ 6.073000000000e-06 3.708155325636e-01
+ 6.074000000000e-06 3.708765117789e-01
+ 6.075000000000e-06 3.709374909941e-01
+ 6.076000000000e-06 3.709984702093e-01
+ 6.077000000000e-06 3.710594494245e-01
+ 6.078000000000e-06 3.711204286397e-01
+ 6.079000000000e-06 3.711814078549e-01
+ 6.080000000000e-06 3.712423870702e-01
+ 6.081000000000e-06 3.713033662854e-01
+ 6.082000000000e-06 3.713643455006e-01
+ 6.083000000000e-06 3.714253247158e-01
+ 6.084000000000e-06 3.714863039310e-01
+ 6.085000000000e-06 3.715472831462e-01
+ 6.086000000000e-06 3.716082623615e-01
+ 6.087000000000e-06 3.716692415767e-01
+ 6.088000000000e-06 3.717302207919e-01
+ 6.089000000000e-06 3.717912000071e-01
+ 6.090000000000e-06 3.718521792223e-01
+ 6.091000000000e-06 3.719131584375e-01
+ 6.092000000000e-06 3.719741376528e-01
+ 6.093000000000e-06 3.720351168680e-01
+ 6.094000000000e-06 3.720960960832e-01
+ 6.095000000000e-06 3.721570752984e-01
+ 6.096000000000e-06 3.722180545136e-01
+ 6.097000000000e-06 3.722790337288e-01
+ 6.098000000000e-06 3.723400129441e-01
+ 6.099000000000e-06 3.724009921593e-01
+ 6.100000000000e-06 3.724619713745e-01
+ 6.101000000000e-06 3.725229505897e-01
+ 6.102000000000e-06 3.725839298049e-01
+ 6.103000000000e-06 3.726449090201e-01
+ 6.104000000000e-06 3.727058882354e-01
+ 6.105000000000e-06 3.727668674506e-01
+ 6.106000000000e-06 3.728278466658e-01
+ 6.107000000000e-06 3.728888258810e-01
+ 6.108000000000e-06 3.729498050962e-01
+ 6.109000000000e-06 3.730107843114e-01
+ 6.110000000000e-06 3.730717635267e-01
+ 6.111000000000e-06 3.731327427419e-01
+ 6.112000000000e-06 3.731937219571e-01
+ 6.113000000000e-06 3.732547011723e-01
+ 6.114000000000e-06 3.733156803875e-01
+ 6.115000000000e-06 3.733766596027e-01
+ 6.116000000000e-06 3.734376388180e-01
+ 6.117000000000e-06 3.734986180332e-01
+ 6.118000000000e-06 3.735595972484e-01
+ 6.119000000000e-06 3.736205764636e-01
+ 6.120000000000e-06 3.736815556788e-01
+ 6.121000000000e-06 3.737425348940e-01
+ 6.122000000000e-06 3.738035141093e-01
+ 6.123000000000e-06 3.738644933245e-01
+ 6.124000000000e-06 3.739254725397e-01
+ 6.125000000000e-06 3.739864517549e-01
+ 6.126000000000e-06 3.740474309701e-01
+ 6.127000000000e-06 3.741084101853e-01
+ 6.128000000000e-06 3.741693894006e-01
+ 6.129000000000e-06 3.742303686158e-01
+ 6.130000000000e-06 3.742913478310e-01
+ 6.131000000000e-06 3.743523270462e-01
+ 6.132000000000e-06 3.744133062614e-01
+ 6.133000000000e-06 3.744742854766e-01
+ 6.134000000000e-06 3.745352646919e-01
+ 6.135000000000e-06 3.745962439071e-01
+ 6.136000000000e-06 3.746572231223e-01
+ 6.137000000000e-06 3.747182023375e-01
+ 6.138000000000e-06 3.747791815527e-01
+ 6.139000000000e-06 3.748401607679e-01
+ 6.140000000000e-06 3.749011399832e-01
+ 6.141000000000e-06 3.749621191984e-01
+ 6.142000000000e-06 3.750230984136e-01
+ 6.143000000000e-06 3.750840776288e-01
+ 6.144000000000e-06 3.751450568440e-01
+ 6.145000000000e-06 3.752060360592e-01
+ 6.146000000000e-06 3.752670152745e-01
+ 6.147000000000e-06 3.753279944897e-01
+ 6.148000000000e-06 3.753889737049e-01
+ 6.149000000000e-06 3.754499529201e-01
+ 6.150000000000e-06 3.755109321353e-01
+ 6.151000000000e-06 3.755719113505e-01
+ 6.152000000000e-06 3.756328905658e-01
+ 6.153000000000e-06 3.756938697810e-01
+ 6.154000000000e-06 3.757548489962e-01
+ 6.155000000000e-06 3.758158282114e-01
+ 6.156000000000e-06 3.758768074266e-01
+ 6.157000000000e-06 3.759377866418e-01
+ 6.158000000000e-06 3.759987658571e-01
+ 6.159000000000e-06 3.760597450723e-01
+ 6.160000000000e-06 3.761207242875e-01
+ 6.161000000000e-06 3.761817035027e-01
+ 6.162000000000e-06 3.762426827179e-01
+ 6.163000000000e-06 3.763036619331e-01
+ 6.164000000000e-06 3.763646411484e-01
+ 6.165000000000e-06 3.764256203636e-01
+ 6.166000000000e-06 3.764865995788e-01
+ 6.167000000000e-06 3.765475787940e-01
+ 6.168000000000e-06 3.766085580092e-01
+ 6.169000000000e-06 3.766695372244e-01
+ 6.170000000000e-06 3.767305164397e-01
+ 6.171000000000e-06 3.767914956549e-01
+ 6.172000000000e-06 3.768524748701e-01
+ 6.173000000000e-06 3.769134540853e-01
+ 6.174000000000e-06 3.769744333005e-01
+ 6.175000000000e-06 3.770354125157e-01
+ 6.176000000000e-06 3.770963917310e-01
+ 6.177000000000e-06 3.771573709462e-01
+ 6.178000000000e-06 3.772183501614e-01
+ 6.179000000000e-06 3.772793293766e-01
+ 6.180000000000e-06 3.773403085918e-01
+ 6.181000000000e-06 3.774012878070e-01
+ 6.182000000000e-06 3.774622670223e-01
+ 6.183000000000e-06 3.775232462375e-01
+ 6.184000000000e-06 3.775842254527e-01
+ 6.185000000000e-06 3.776452046679e-01
+ 6.186000000000e-06 3.777061838831e-01
+ 6.187000000000e-06 3.777671630983e-01
+ 6.188000000000e-06 3.778281423136e-01
+ 6.189000000000e-06 3.778891215288e-01
+ 6.190000000000e-06 3.779501007440e-01
+ 6.191000000000e-06 3.780110799592e-01
+ 6.192000000000e-06 3.780720591744e-01
+ 6.193000000000e-06 3.781330383896e-01
+ 6.194000000000e-06 3.781940176049e-01
+ 6.195000000000e-06 3.782549968201e-01
+ 6.196000000000e-06 3.783159760353e-01
+ 6.197000000000e-06 3.783769552505e-01
+ 6.198000000000e-06 3.784379344657e-01
+ 6.199000000000e-06 3.784989136809e-01
+ 6.200000000000e-06 3.785598928962e-01
+ 6.201000000000e-06 3.786208721114e-01
+ 6.202000000000e-06 3.786818513266e-01
+ 6.203000000000e-06 3.787428305418e-01
+ 6.204000000000e-06 3.788038097570e-01
+ 6.205000000000e-06 3.788647889722e-01
+ 6.206000000000e-06 3.789257681875e-01
+ 6.207000000000e-06 3.789867474027e-01
+ 6.208000000000e-06 3.790477266179e-01
+ 6.209000000000e-06 3.791087058331e-01
+ 6.210000000000e-06 3.791696850483e-01
+ 6.211000000000e-06 3.792306642635e-01
+ 6.212000000000e-06 3.792916434788e-01
+ 6.213000000000e-06 3.793526226940e-01
+ 6.214000000000e-06 3.794136019092e-01
+ 6.215000000000e-06 3.794745811244e-01
+ 6.216000000000e-06 3.795355603396e-01
+ 6.217000000000e-06 3.795965395548e-01
+ 6.218000000000e-06 3.796575187701e-01
+ 6.219000000000e-06 3.797184979853e-01
+ 6.220000000000e-06 3.797794772005e-01
+ 6.221000000000e-06 3.798404564157e-01
+ 6.222000000000e-06 3.799014356309e-01
+ 6.223000000000e-06 3.799624148461e-01
+ 6.224000000000e-06 3.800233940614e-01
+ 6.225000000000e-06 3.800843732766e-01
+ 6.226000000000e-06 3.801453524918e-01
+ 6.227000000000e-06 3.802063317070e-01
+ 6.228000000000e-06 3.802673109222e-01
+ 6.229000000000e-06 3.803282901374e-01
+ 6.230000000000e-06 3.803892693527e-01
+ 6.231000000000e-06 3.804502485679e-01
+ 6.232000000000e-06 3.805112277831e-01
+ 6.233000000000e-06 3.805722069983e-01
+ 6.234000000000e-06 3.806331862135e-01
+ 6.235000000000e-06 3.806941654287e-01
+ 6.236000000000e-06 3.807551446440e-01
+ 6.237000000000e-06 3.808161238592e-01
+ 6.238000000000e-06 3.808771030744e-01
+ 6.239000000000e-06 3.809380822896e-01
+ 6.240000000000e-06 3.809990615048e-01
+ 6.241000000000e-06 3.810600407200e-01
+ 6.242000000000e-06 3.811210199353e-01
+ 6.243000000000e-06 3.811819991505e-01
+ 6.244000000000e-06 3.812429783657e-01
+ 6.245000000000e-06 3.813039575809e-01
+ 6.246000000000e-06 3.813649367961e-01
+ 6.247000000000e-06 3.814259160113e-01
+ 6.248000000000e-06 3.814868952266e-01
+ 6.249000000000e-06 3.815478744418e-01
+ 6.250000000000e-06 3.816088536570e-01
+ 6.251000000000e-06 3.816698328722e-01
+ 6.252000000000e-06 3.817308120874e-01
+ 6.253000000000e-06 3.817917913026e-01
+ 6.254000000000e-06 3.818527705179e-01
+ 6.255000000000e-06 3.819137497331e-01
+ 6.256000000000e-06 3.819747289483e-01
+ 6.257000000000e-06 3.820357081635e-01
+ 6.258000000000e-06 3.820966873787e-01
+ 6.259000000000e-06 3.821576665939e-01
+ 6.260000000000e-06 3.822186458091e-01
+ 6.261000000000e-06 3.822796250244e-01
+ 6.262000000000e-06 3.823406042396e-01
+ 6.263000000000e-06 3.824015834548e-01
+ 6.264000000000e-06 3.824625626700e-01
+ 6.265000000000e-06 3.825235418852e-01
+ 6.266000000000e-06 3.825845211004e-01
+ 6.267000000000e-06 3.826455003157e-01
+ 6.268000000000e-06 3.827064795309e-01
+ 6.269000000000e-06 3.827674587461e-01
+ 6.270000000000e-06 3.828284379613e-01
+ 6.271000000000e-06 3.828894171765e-01
+ 6.272000000000e-06 3.829503963917e-01
+ 6.273000000000e-06 3.830113756070e-01
+ 6.274000000000e-06 3.830723548222e-01
+ 6.275000000000e-06 3.831333340374e-01
+ 6.276000000000e-06 3.831943132526e-01
+ 6.277000000000e-06 3.832552924678e-01
+ 6.278000000000e-06 3.833162716830e-01
+ 6.279000000000e-06 3.833772508983e-01
+ 6.280000000000e-06 3.834382301135e-01
+ 6.281000000000e-06 3.834992093287e-01
+ 6.282000000000e-06 3.835601885439e-01
+ 6.283000000000e-06 3.836211677591e-01
+ 6.284000000000e-06 3.836821469743e-01
+ 6.285000000000e-06 3.837431261896e-01
+ 6.286000000000e-06 3.838041054048e-01
+ 6.287000000000e-06 3.838650846200e-01
+ 6.288000000000e-06 3.839260638352e-01
+ 6.289000000000e-06 3.839870430504e-01
+ 6.290000000000e-06 3.840480222656e-01
+ 6.291000000000e-06 3.841090014809e-01
+ 6.292000000000e-06 3.841699806961e-01
+ 6.293000000000e-06 3.842309599113e-01
+ 6.294000000000e-06 3.842919391265e-01
+ 6.295000000000e-06 3.843529183417e-01
+ 6.296000000000e-06 3.844138975569e-01
+ 6.297000000000e-06 3.844748767722e-01
+ 6.298000000000e-06 3.845358559874e-01
+ 6.299000000000e-06 3.845968352026e-01
+ 6.300000000000e-06 3.846578144178e-01
+ 6.301000000000e-06 3.847187936330e-01
+ 6.302000000000e-06 3.847797728482e-01
+ 6.303000000000e-06 3.848407520635e-01
+ 6.304000000000e-06 3.849017312787e-01
+ 6.305000000000e-06 3.849627104939e-01
+ 6.306000000000e-06 3.850236897091e-01
+ 6.307000000000e-06 3.850846689243e-01
+ 6.308000000000e-06 3.851456481395e-01
+ 6.309000000000e-06 3.852066273548e-01
+ 6.310000000000e-06 3.852676065700e-01
+ 6.311000000000e-06 3.853285857852e-01
+ 6.312000000000e-06 3.853895650004e-01
+ 6.313000000000e-06 3.854505442156e-01
+ 6.314000000000e-06 3.855115234308e-01
+ 6.315000000000e-06 3.855725026461e-01
+ 6.316000000000e-06 3.856334818613e-01
+ 6.317000000000e-06 3.856944610765e-01
+ 6.318000000000e-06 3.857554402917e-01
+ 6.319000000000e-06 3.858164195069e-01
+ 6.320000000000e-06 3.858773987221e-01
+ 6.321000000000e-06 3.859383779374e-01
+ 6.322000000000e-06 3.859993571526e-01
+ 6.323000000000e-06 3.860603363678e-01
+ 6.324000000000e-06 3.861213155830e-01
+ 6.325000000000e-06 3.861822947982e-01
+ 6.326000000000e-06 3.862432740134e-01
+ 6.327000000000e-06 3.863042532287e-01
+ 6.328000000000e-06 3.863652324439e-01
+ 6.329000000000e-06 3.864262116591e-01
+ 6.330000000000e-06 3.864871908743e-01
+ 6.331000000000e-06 3.865481700895e-01
+ 6.332000000000e-06 3.866091493047e-01
+ 6.333000000000e-06 3.866701285200e-01
+ 6.334000000000e-06 3.867311077352e-01
+ 6.335000000000e-06 3.867920869504e-01
+ 6.336000000000e-06 3.868530661656e-01
+ 6.337000000000e-06 3.869140453808e-01
+ 6.338000000000e-06 3.869750245960e-01
+ 6.339000000000e-06 3.870360038113e-01
+ 6.340000000000e-06 3.870969830265e-01
+ 6.341000000000e-06 3.871579622417e-01
+ 6.342000000000e-06 3.872189414569e-01
+ 6.343000000000e-06 3.872799206721e-01
+ 6.344000000000e-06 3.873408998873e-01
+ 6.345000000000e-06 3.874018791026e-01
+ 6.346000000000e-06 3.874628583178e-01
+ 6.347000000000e-06 3.875238375330e-01
+ 6.348000000000e-06 3.875848167482e-01
+ 6.349000000000e-06 3.876457959634e-01
+ 6.350000000000e-06 3.877067751786e-01
+ 6.351000000000e-06 3.877677543939e-01
+ 6.352000000000e-06 3.878287336091e-01
+ 6.353000000000e-06 3.878897128243e-01
+ 6.354000000000e-06 3.879506920395e-01
+ 6.355000000000e-06 3.880116712547e-01
+ 6.356000000000e-06 3.880726504699e-01
+ 6.357000000000e-06 3.881336296852e-01
+ 6.358000000000e-06 3.881946089004e-01
+ 6.359000000000e-06 3.882555881156e-01
+ 6.360000000000e-06 3.883165673308e-01
+ 6.361000000000e-06 3.883775465460e-01
+ 6.362000000000e-06 3.884385257612e-01
+ 6.363000000000e-06 3.884995049765e-01
+ 6.364000000000e-06 3.885604841917e-01
+ 6.365000000000e-06 3.886214634069e-01
+ 6.366000000000e-06 3.886824426221e-01
+ 6.367000000000e-06 3.887434218373e-01
+ 6.368000000000e-06 3.888044010525e-01
+ 6.369000000000e-06 3.888653802678e-01
+ 6.370000000000e-06 3.889263594830e-01
+ 6.371000000000e-06 3.889873386982e-01
+ 6.372000000000e-06 3.890483179134e-01
+ 6.373000000000e-06 3.891092971286e-01
+ 6.374000000000e-06 3.891702763438e-01
+ 6.375000000000e-06 3.892312555591e-01
+ 6.376000000000e-06 3.892922347743e-01
+ 6.377000000000e-06 3.893532139895e-01
+ 6.378000000000e-06 3.894141932047e-01
+ 6.379000000000e-06 3.894751724199e-01
+ 6.380000000000e-06 3.895361516351e-01
+ 6.381000000000e-06 3.895971308504e-01
+ 6.382000000000e-06 3.896581100656e-01
+ 6.383000000000e-06 3.897190892808e-01
+ 6.384000000000e-06 3.897800684960e-01
+ 6.385000000000e-06 3.898410477112e-01
+ 6.386000000000e-06 3.899020269264e-01
+ 6.387000000000e-06 3.899630061417e-01
+ 6.388000000000e-06 3.900239853569e-01
+ 6.389000000000e-06 3.900849645721e-01
+ 6.390000000000e-06 3.901459437873e-01
+ 6.391000000000e-06 3.902069230025e-01
+ 6.392000000000e-06 3.902679022177e-01
+ 6.393000000000e-06 3.903288814330e-01
+ 6.394000000000e-06 3.903898606482e-01
+ 6.395000000000e-06 3.904508398634e-01
+ 6.396000000000e-06 3.905118190786e-01
+ 6.397000000000e-06 3.905727982938e-01
+ 6.398000000000e-06 3.906337775090e-01
+ 6.399000000000e-06 3.906947567243e-01
+ 6.400000000000e-06 3.907557359395e-01
+ 6.401000000000e-06 3.908167151547e-01
+ 6.402000000000e-06 3.908776943699e-01
+ 6.403000000000e-06 3.909386735851e-01
+ 6.404000000000e-06 3.909996528003e-01
+ 6.405000000000e-06 3.910606320156e-01
+ 6.406000000000e-06 3.911216112308e-01
+ 6.407000000000e-06 3.911825904460e-01
+ 6.408000000000e-06 3.912435696612e-01
+ 6.409000000000e-06 3.913045488764e-01
+ 6.410000000000e-06 3.913655280916e-01
+ 6.411000000000e-06 3.914265073069e-01
+ 6.412000000000e-06 3.914874865221e-01
+ 6.413000000000e-06 3.915484657373e-01
+ 6.414000000000e-06 3.916094449525e-01
+ 6.415000000000e-06 3.916704241677e-01
+ 6.416000000000e-06 3.917314033829e-01
+ 6.417000000000e-06 3.917923825982e-01
+ 6.418000000000e-06 3.918533618134e-01
+ 6.419000000000e-06 3.919143410286e-01
+ 6.420000000000e-06 3.919753202438e-01
+ 6.421000000000e-06 3.920362994590e-01
+ 6.422000000000e-06 3.920972786742e-01
+ 6.423000000000e-06 3.921582578895e-01
+ 6.424000000000e-06 3.922192371047e-01
+ 6.425000000000e-06 3.922802163199e-01
+ 6.426000000000e-06 3.923411955351e-01
+ 6.427000000000e-06 3.924021747503e-01
+ 6.428000000000e-06 3.924631539655e-01
+ 6.429000000000e-06 3.925241331808e-01
+ 6.430000000000e-06 3.925851123960e-01
+ 6.431000000000e-06 3.926460916112e-01
+ 6.432000000000e-06 3.927070708264e-01
+ 6.433000000000e-06 3.927680500416e-01
+ 6.434000000000e-06 3.928290292568e-01
+ 6.435000000000e-06 3.928900084721e-01
+ 6.436000000000e-06 3.929509876873e-01
+ 6.437000000000e-06 3.930119669025e-01
+ 6.438000000000e-06 3.930729461177e-01
+ 6.439000000000e-06 3.931339253329e-01
+ 6.440000000000e-06 3.931949045481e-01
+ 6.441000000000e-06 3.932558837634e-01
+ 6.442000000000e-06 3.933168629786e-01
+ 6.443000000000e-06 3.933778421938e-01
+ 6.444000000000e-06 3.934388214090e-01
+ 6.445000000000e-06 3.934998006242e-01
+ 6.446000000000e-06 3.935607798394e-01
+ 6.447000000000e-06 3.936217590547e-01
+ 6.448000000000e-06 3.936827382699e-01
+ 6.449000000000e-06 3.937437174851e-01
+ 6.450000000000e-06 3.938046967003e-01
+ 6.451000000000e-06 3.938656759155e-01
+ 6.452000000000e-06 3.939266551307e-01
+ 6.453000000000e-06 3.939876343460e-01
+ 6.454000000000e-06 3.940486135612e-01
+ 6.455000000000e-06 3.941095927764e-01
+ 6.456000000000e-06 3.941705719916e-01
+ 6.457000000000e-06 3.942315512068e-01
+ 6.458000000000e-06 3.942925304220e-01
+ 6.459000000000e-06 3.943535096373e-01
+ 6.460000000000e-06 3.944144888525e-01
+ 6.461000000000e-06 3.944754680677e-01
+ 6.462000000000e-06 3.945364472829e-01
+ 6.463000000000e-06 3.945974264981e-01
+ 6.464000000000e-06 3.946584057133e-01
+ 6.465000000000e-06 3.947193849286e-01
+ 6.466000000000e-06 3.947803641438e-01
+ 6.467000000000e-06 3.948413433590e-01
+ 6.468000000000e-06 3.949023225742e-01
+ 6.469000000000e-06 3.949633017894e-01
+ 6.470000000000e-06 3.950242810046e-01
+ 6.471000000000e-06 3.950852602199e-01
+ 6.472000000000e-06 3.951462394351e-01
+ 6.473000000000e-06 3.952072186503e-01
+ 6.474000000000e-06 3.952681978655e-01
+ 6.475000000000e-06 3.953291770807e-01
+ 6.476000000000e-06 3.953901562959e-01
+ 6.477000000000e-06 3.954511355112e-01
+ 6.478000000000e-06 3.955121147264e-01
+ 6.479000000000e-06 3.955730939416e-01
+ 6.480000000000e-06 3.956340731568e-01
+ 6.481000000000e-06 3.956950523720e-01
+ 6.482000000000e-06 3.957560315872e-01
+ 6.483000000000e-06 3.958170108025e-01
+ 6.484000000000e-06 3.958779900177e-01
+ 6.485000000000e-06 3.959389692329e-01
+ 6.486000000000e-06 3.959999484481e-01
+ 6.487000000000e-06 3.960609276633e-01
+ 6.488000000000e-06 3.961219068785e-01
+ 6.489000000000e-06 3.961828860937e-01
+ 6.490000000000e-06 3.962438653090e-01
+ 6.491000000000e-06 3.963048445242e-01
+ 6.492000000000e-06 3.963658237394e-01
+ 6.493000000000e-06 3.964268029546e-01
+ 6.494000000000e-06 3.964877821698e-01
+ 6.495000000000e-06 3.965487613850e-01
+ 6.496000000000e-06 3.966097406003e-01
+ 6.497000000000e-06 3.966707198155e-01
+ 6.498000000000e-06 3.967316990307e-01
+ 6.499000000000e-06 3.967926782459e-01
+ 6.500000000000e-06 3.968536574611e-01
+ 6.501000000000e-06 3.969146366763e-01
+ 6.502000000000e-06 3.969756158916e-01
+ 6.503000000000e-06 3.970365951068e-01
+ 6.504000000000e-06 3.970975743220e-01
+ 6.505000000000e-06 3.971585535372e-01
+ 6.506000000000e-06 3.972195327524e-01
+ 6.507000000000e-06 3.972805119676e-01
+ 6.508000000000e-06 3.973414911829e-01
+ 6.509000000000e-06 3.974024703981e-01
+ 6.510000000000e-06 3.974634496133e-01
+ 6.511000000000e-06 3.975244288285e-01
+ 6.512000000000e-06 3.975854080437e-01
+ 6.513000000000e-06 3.976463872589e-01
+ 6.514000000000e-06 3.977073664742e-01
+ 6.515000000000e-06 3.977683456894e-01
+ 6.516000000000e-06 3.978293249046e-01
+ 6.517000000000e-06 3.978903041198e-01
+ 6.518000000000e-06 3.979512833350e-01
+ 6.519000000000e-06 3.980122625502e-01
+ 6.520000000000e-06 3.980732417655e-01
+ 6.521000000000e-06 3.981342209807e-01
+ 6.522000000000e-06 3.981952001959e-01
+ 6.523000000000e-06 3.982561794111e-01
+ 6.524000000000e-06 3.983171586263e-01
+ 6.525000000000e-06 3.983781378415e-01
+ 6.526000000000e-06 3.984391170568e-01
+ 6.527000000000e-06 3.985000962720e-01
+ 6.528000000000e-06 3.985610754872e-01
+ 6.529000000000e-06 3.986220547024e-01
+ 6.530000000000e-06 3.986830339176e-01
+ 6.531000000000e-06 3.987440131328e-01
+ 6.532000000000e-06 3.988049923481e-01
+ 6.533000000000e-06 3.988659715633e-01
+ 6.534000000000e-06 3.989269507785e-01
+ 6.535000000000e-06 3.989879299937e-01
+ 6.536000000000e-06 3.990489092089e-01
+ 6.537000000000e-06 3.991098884241e-01
+ 6.538000000000e-06 3.991708676394e-01
+ 6.539000000000e-06 3.992318468546e-01
+ 6.540000000000e-06 3.992928260698e-01
+ 6.541000000000e-06 3.993538052850e-01
+ 6.542000000000e-06 3.994147845002e-01
+ 6.543000000000e-06 3.994757637154e-01
+ 6.544000000000e-06 3.995367429307e-01
+ 6.545000000000e-06 3.995977221459e-01
+ 6.546000000000e-06 3.996587013611e-01
+ 6.547000000000e-06 3.997196805763e-01
+ 6.548000000000e-06 3.997806597915e-01
+ 6.549000000000e-06 3.998416390067e-01
+ 6.550000000000e-06 3.999026182220e-01
+ 6.551000000000e-06 3.999635974372e-01
+ 6.552000000000e-06 4.000245766524e-01
+ 6.553000000000e-06 4.000855558676e-01
+ 6.554000000000e-06 4.001465350828e-01
+ 6.555000000000e-06 4.002075142980e-01
+ 6.556000000000e-06 4.002684935133e-01
+ 6.557000000000e-06 4.003294727285e-01
+ 6.558000000000e-06 4.003904519437e-01
+ 6.559000000000e-06 4.004514311589e-01
+ 6.560000000000e-06 4.005124103741e-01
+ 6.561000000000e-06 4.005733895893e-01
+ 6.562000000000e-06 4.006343688046e-01
+ 6.563000000000e-06 4.006953480198e-01
+ 6.564000000000e-06 4.007563272350e-01
+ 6.565000000000e-06 4.008173064502e-01
+ 6.566000000000e-06 4.008782856654e-01
+ 6.567000000000e-06 4.009392648806e-01
+ 6.568000000000e-06 4.010002440959e-01
+ 6.569000000000e-06 4.010612233111e-01
+ 6.570000000000e-06 4.011222025263e-01
+ 6.571000000000e-06 4.011831817415e-01
+ 6.572000000000e-06 4.012441609567e-01
+ 6.573000000000e-06 4.013051401719e-01
+ 6.574000000000e-06 4.013661193872e-01
+ 6.575000000000e-06 4.014270986024e-01
+ 6.576000000000e-06 4.014880778176e-01
+ 6.577000000000e-06 4.015490570328e-01
+ 6.578000000000e-06 4.016100362480e-01
+ 6.579000000000e-06 4.016710154632e-01
+ 6.580000000000e-06 4.017319946785e-01
+ 6.581000000000e-06 4.017929738937e-01
+ 6.582000000000e-06 4.018539531089e-01
+ 6.583000000000e-06 4.019149323241e-01
+ 6.584000000000e-06 4.019759115393e-01
+ 6.585000000000e-06 4.020368907545e-01
+ 6.586000000000e-06 4.020978699698e-01
+ 6.587000000000e-06 4.021588491850e-01
+ 6.588000000000e-06 4.022198284002e-01
+ 6.589000000000e-06 4.022808076154e-01
+ 6.590000000000e-06 4.023417868306e-01
+ 6.591000000000e-06 4.024027660458e-01
+ 6.592000000000e-06 4.024637452611e-01
+ 6.593000000000e-06 4.025247244763e-01
+ 6.594000000000e-06 4.025857036915e-01
+ 6.595000000000e-06 4.026466829067e-01
+ 6.596000000000e-06 4.027076621219e-01
+ 6.597000000000e-06 4.027686413371e-01
+ 6.598000000000e-06 4.028296205524e-01
+ 6.599000000000e-06 4.028905997676e-01
+ 6.600000000000e-06 4.029515789828e-01
+ 6.601000000000e-06 4.030125581980e-01
+ 6.602000000000e-06 4.030735374132e-01
+ 6.603000000000e-06 4.031345166284e-01
+ 6.604000000000e-06 4.031954958437e-01
+ 6.605000000000e-06 4.032564750589e-01
+ 6.606000000000e-06 4.033174542741e-01
+ 6.607000000000e-06 4.033784334893e-01
+ 6.608000000000e-06 4.034394127045e-01
+ 6.609000000000e-06 4.035003919197e-01
+ 6.610000000000e-06 4.035613711350e-01
+ 6.611000000000e-06 4.036223503502e-01
+ 6.612000000000e-06 4.036833295654e-01
+ 6.613000000000e-06 4.037443087806e-01
+ 6.614000000000e-06 4.038052879958e-01
+ 6.615000000000e-06 4.038662672110e-01
+ 6.616000000000e-06 4.039272464263e-01
+ 6.617000000000e-06 4.039882256415e-01
+ 6.618000000000e-06 4.040492048567e-01
+ 6.619000000000e-06 4.041101840719e-01
+ 6.620000000000e-06 4.041711632871e-01
+ 6.621000000000e-06 4.042321425023e-01
+ 6.622000000000e-06 4.042931217176e-01
+ 6.623000000000e-06 4.043541009328e-01
+ 6.624000000000e-06 4.044150801480e-01
+ 6.625000000000e-06 4.044760593632e-01
+ 6.626000000000e-06 4.045370385784e-01
+ 6.627000000000e-06 4.045980177936e-01
+ 6.628000000000e-06 4.046589970089e-01
+ 6.629000000000e-06 4.047199762241e-01
+ 6.630000000000e-06 4.047809554393e-01
+ 6.631000000000e-06 4.048419346545e-01
+ 6.632000000000e-06 4.049029138697e-01
+ 6.633000000000e-06 4.049638930849e-01
+ 6.634000000000e-06 4.050248723002e-01
+ 6.635000000000e-06 4.050858515154e-01
+ 6.636000000000e-06 4.051468307306e-01
+ 6.637000000000e-06 4.052078099458e-01
+ 6.638000000000e-06 4.052687891610e-01
+ 6.639000000000e-06 4.053297683762e-01
+ 6.640000000000e-06 4.053907475915e-01
+ 6.641000000000e-06 4.054517268067e-01
+ 6.642000000000e-06 4.055127060219e-01
+ 6.643000000000e-06 4.055736852371e-01
+ 6.644000000000e-06 4.056346644523e-01
+ 6.645000000000e-06 4.056956436675e-01
+ 6.646000000000e-06 4.057566228828e-01
+ 6.647000000000e-06 4.058176020980e-01
+ 6.648000000000e-06 4.058785813132e-01
+ 6.649000000000e-06 4.059395605284e-01
+ 6.650000000000e-06 4.060005397436e-01
+ 6.651000000000e-06 4.060615189588e-01
+ 6.652000000000e-06 4.061224981741e-01
+ 6.653000000000e-06 4.061834773893e-01
+ 6.654000000000e-06 4.062444566045e-01
+ 6.655000000000e-06 4.063054358197e-01
+ 6.656000000000e-06 4.063664150349e-01
+ 6.657000000000e-06 4.064273942501e-01
+ 6.658000000000e-06 4.064883734654e-01
+ 6.659000000000e-06 4.065493526806e-01
+ 6.660000000000e-06 4.066103318958e-01
+ 6.661000000000e-06 4.066713111110e-01
+ 6.662000000000e-06 4.067322903262e-01
+ 6.663000000000e-06 4.067932695414e-01
+ 6.664000000000e-06 4.068542487567e-01
+ 6.665000000000e-06 4.069152279719e-01
+ 6.666000000000e-06 4.069762071871e-01
+ 6.667000000000e-06 4.070371864023e-01
+ 6.668000000000e-06 4.070981656175e-01
+ 6.669000000000e-06 4.071591448327e-01
+ 6.670000000000e-06 4.072201240480e-01
+ 6.671000000000e-06 4.072811032632e-01
+ 6.672000000000e-06 4.073420824784e-01
+ 6.673000000000e-06 4.074030616936e-01
+ 6.674000000000e-06 4.074640409088e-01
+ 6.675000000000e-06 4.075250201240e-01
+ 6.676000000000e-06 4.075859993393e-01
+ 6.677000000000e-06 4.076469785545e-01
+ 6.678000000000e-06 4.077079577697e-01
+ 6.679000000000e-06 4.077689369849e-01
+ 6.680000000000e-06 4.078299162001e-01
+ 6.681000000000e-06 4.078908954153e-01
+ 6.682000000000e-06 4.079518746306e-01
+ 6.683000000000e-06 4.080128538458e-01
+ 6.684000000000e-06 4.080738330610e-01
+ 6.685000000000e-06 4.081348122762e-01
+ 6.686000000000e-06 4.081957914914e-01
+ 6.687000000000e-06 4.082567707066e-01
+ 6.688000000000e-06 4.083177499219e-01
+ 6.689000000000e-06 4.083787291371e-01
+ 6.690000000000e-06 4.084397083523e-01
+ 6.691000000000e-06 4.085006875675e-01
+ 6.692000000000e-06 4.085616667827e-01
+ 6.693000000000e-06 4.086226459979e-01
+ 6.694000000000e-06 4.086836252132e-01
+ 6.695000000000e-06 4.087446044284e-01
+ 6.696000000000e-06 4.088055836436e-01
+ 6.697000000000e-06 4.088665628588e-01
+ 6.698000000000e-06 4.089275420740e-01
+ 6.699000000000e-06 4.089885212892e-01
+ 6.700000000000e-06 4.090495005045e-01
+ 6.701000000000e-06 4.091104797197e-01
+ 6.702000000000e-06 4.091714589349e-01
+ 6.703000000000e-06 4.092324381501e-01
+ 6.704000000000e-06 4.092934173653e-01
+ 6.705000000000e-06 4.093543965805e-01
+ 6.706000000000e-06 4.094153757958e-01
+ 6.707000000000e-06 4.094763550110e-01
+ 6.708000000000e-06 4.095373342262e-01
+ 6.709000000000e-06 4.095983134414e-01
+ 6.710000000000e-06 4.096592926566e-01
+ 6.711000000000e-06 4.097202718718e-01
+ 6.712000000000e-06 4.097812510870e-01
+ 6.713000000000e-06 4.098422303023e-01
+ 6.714000000000e-06 4.099032095175e-01
+ 6.715000000000e-06 4.099641887327e-01
+ 6.716000000000e-06 4.100251679479e-01
+ 6.717000000000e-06 4.100861471631e-01
+ 6.718000000000e-06 4.101471263783e-01
+ 6.719000000000e-06 4.102081055936e-01
+ 6.720000000000e-06 4.102690848088e-01
+ 6.721000000000e-06 4.103300640240e-01
+ 6.722000000000e-06 4.103910432392e-01
+ 6.723000000000e-06 4.104520224544e-01
+ 6.724000000000e-06 4.105130016696e-01
+ 6.725000000000e-06 4.105739808849e-01
+ 6.726000000000e-06 4.106349601001e-01
+ 6.727000000000e-06 4.106959393153e-01
+ 6.728000000000e-06 4.107569185305e-01
+ 6.729000000000e-06 4.108178977457e-01
+ 6.730000000000e-06 4.108788769609e-01
+ 6.731000000000e-06 4.109398561762e-01
+ 6.732000000000e-06 4.110008353914e-01
+ 6.733000000000e-06 4.110618146066e-01
+ 6.734000000000e-06 4.111227938218e-01
+ 6.735000000000e-06 4.111837730370e-01
+ 6.736000000000e-06 4.112447522522e-01
+ 6.737000000000e-06 4.113057314675e-01
+ 6.738000000000e-06 4.113667106827e-01
+ 6.739000000000e-06 4.114276898979e-01
+ 6.740000000000e-06 4.114886691131e-01
+ 6.741000000000e-06 4.115496483283e-01
+ 6.742000000000e-06 4.116106275435e-01
+ 6.743000000000e-06 4.116716067588e-01
+ 6.744000000000e-06 4.117325859740e-01
+ 6.745000000000e-06 4.117935651892e-01
+ 6.746000000000e-06 4.118545444044e-01
+ 6.747000000000e-06 4.119155236196e-01
+ 6.748000000000e-06 4.119765028348e-01
+ 6.749000000000e-06 4.120374820501e-01
+ 6.750000000000e-06 4.120984612653e-01
+ 6.751000000000e-06 4.121594404805e-01
+ 6.752000000000e-06 4.122204196957e-01
+ 6.753000000000e-06 4.122813989109e-01
+ 6.754000000000e-06 4.123423781261e-01
+ 6.755000000000e-06 4.124033573414e-01
+ 6.756000000000e-06 4.124643365566e-01
+ 6.757000000000e-06 4.125253157718e-01
+ 6.758000000000e-06 4.125862949870e-01
+ 6.759000000000e-06 4.126472742022e-01
+ 6.760000000000e-06 4.127082534174e-01
+ 6.761000000000e-06 4.127692326327e-01
+ 6.762000000000e-06 4.128302118479e-01
+ 6.763000000000e-06 4.128911910631e-01
+ 6.764000000000e-06 4.129521702783e-01
+ 6.765000000000e-06 4.130131494935e-01
+ 6.766000000000e-06 4.130741287087e-01
+ 6.767000000000e-06 4.131351079240e-01
+ 6.768000000000e-06 4.131960871392e-01
+ 6.769000000000e-06 4.132570663544e-01
+ 6.770000000000e-06 4.133180455696e-01
+ 6.771000000000e-06 4.133790247848e-01
+ 6.772000000000e-06 4.134400040000e-01
+ 6.773000000000e-06 4.135009832153e-01
+ 6.774000000000e-06 4.135619624305e-01
+ 6.775000000000e-06 4.136229416457e-01
+ 6.776000000000e-06 4.136839208609e-01
+ 6.777000000000e-06 4.137449000761e-01
+ 6.778000000000e-06 4.138058792913e-01
+ 6.779000000000e-06 4.138668585066e-01
+ 6.780000000000e-06 4.139278377218e-01
+ 6.781000000000e-06 4.139888169370e-01
+ 6.782000000000e-06 4.140497961522e-01
+ 6.783000000000e-06 4.141107753674e-01
+ 6.784000000000e-06 4.141717545826e-01
+ 6.785000000000e-06 4.142327337979e-01
+ 6.786000000000e-06 4.142937130131e-01
+ 6.787000000000e-06 4.143546922283e-01
+ 6.788000000000e-06 4.144156714435e-01
+ 6.789000000000e-06 4.144766506587e-01
+ 6.790000000000e-06 4.145376298739e-01
+ 6.791000000000e-06 4.145986090892e-01
+ 6.792000000000e-06 4.146595883044e-01
+ 6.793000000000e-06 4.147205675196e-01
+ 6.794000000000e-06 4.147815467348e-01
+ 6.795000000000e-06 4.148425259500e-01
+ 6.796000000000e-06 4.149035051652e-01
+ 6.797000000000e-06 4.149644843805e-01
+ 6.798000000000e-06 4.150254635957e-01
+ 6.799000000000e-06 4.150864428109e-01
+ 6.800000000000e-06 4.151474220261e-01
+ 6.801000000000e-06 4.152084012413e-01
+ 6.802000000000e-06 4.152693804565e-01
+ 6.803000000000e-06 4.153303596718e-01
+ 6.804000000000e-06 4.153913388870e-01
+ 6.805000000000e-06 4.154523181022e-01
+ 6.806000000000e-06 4.155132973174e-01
+ 6.807000000000e-06 4.155742765326e-01
+ 6.808000000000e-06 4.156352557478e-01
+ 6.809000000000e-06 4.156962349631e-01
+ 6.810000000000e-06 4.157572141783e-01
+ 6.811000000000e-06 4.158181933935e-01
+ 6.812000000000e-06 4.158791726087e-01
+ 6.813000000000e-06 4.159401518239e-01
+ 6.814000000000e-06 4.160011310391e-01
+ 6.815000000000e-06 4.160621102544e-01
+ 6.816000000000e-06 4.161230894696e-01
+ 6.817000000000e-06 4.161840686848e-01
+ 6.818000000000e-06 4.162450479000e-01
+ 6.819000000000e-06 4.163060271152e-01
+ 6.820000000000e-06 4.163670063304e-01
+ 6.821000000000e-06 4.164279855457e-01
+ 6.822000000000e-06 4.164889647609e-01
+ 6.823000000000e-06 4.165499439761e-01
+ 6.824000000000e-06 4.166109231913e-01
+ 6.825000000000e-06 4.166719024065e-01
+ 6.826000000000e-06 4.167328816217e-01
+ 6.827000000000e-06 4.167938608370e-01
+ 6.828000000000e-06 4.168548400522e-01
+ 6.829000000000e-06 4.169158192674e-01
+ 6.830000000000e-06 4.169767984826e-01
+ 6.831000000000e-06 4.170377776978e-01
+ 6.832000000000e-06 4.170987569130e-01
+ 6.833000000000e-06 4.171597361283e-01
+ 6.834000000000e-06 4.172207153435e-01
+ 6.835000000000e-06 4.172816945587e-01
+ 6.836000000000e-06 4.173426737739e-01
+ 6.837000000000e-06 4.174036529891e-01
+ 6.838000000000e-06 4.174646322043e-01
+ 6.839000000000e-06 4.175256114196e-01
+ 6.840000000000e-06 4.175865906348e-01
+ 6.841000000000e-06 4.176475698500e-01
+ 6.842000000000e-06 4.177085490652e-01
+ 6.843000000000e-06 4.177695282804e-01
+ 6.844000000000e-06 4.178305074956e-01
+ 6.845000000000e-06 4.178914867109e-01
+ 6.846000000000e-06 4.179524659261e-01
+ 6.847000000000e-06 4.180134451413e-01
+ 6.848000000000e-06 4.180744243565e-01
+ 6.849000000000e-06 4.181354035717e-01
+ 6.850000000000e-06 4.181963827869e-01
+ 6.851000000000e-06 4.182573620022e-01
+ 6.852000000000e-06 4.183183412174e-01
+ 6.853000000000e-06 4.183793204326e-01
+ 6.854000000000e-06 4.184402996478e-01
+ 6.855000000000e-06 4.185012788630e-01
+ 6.856000000000e-06 4.185622580782e-01
+ 6.857000000000e-06 4.186232372935e-01
+ 6.858000000000e-06 4.186842165087e-01
+ 6.859000000000e-06 4.187451957239e-01
+ 6.860000000000e-06 4.188061749391e-01
+ 6.861000000000e-06 4.188671541543e-01
+ 6.862000000000e-06 4.189281333695e-01
+ 6.863000000000e-06 4.189891125848e-01
+ 6.864000000000e-06 4.190500918000e-01
+ 6.865000000000e-06 4.191110710152e-01
+ 6.866000000000e-06 4.191720502304e-01
+ 6.867000000000e-06 4.192330294456e-01
+ 6.868000000000e-06 4.192940086608e-01
+ 6.869000000000e-06 4.193549878761e-01
+ 6.870000000000e-06 4.194159670913e-01
+ 6.871000000000e-06 4.194769463065e-01
+ 6.872000000000e-06 4.195379255217e-01
+ 6.873000000000e-06 4.195989047369e-01
+ 6.874000000000e-06 4.196598839521e-01
+ 6.875000000000e-06 4.197208631674e-01
+ 6.876000000000e-06 4.197818423826e-01
+ 6.877000000000e-06 4.198428215978e-01
+ 6.878000000000e-06 4.199038008130e-01
+ 6.879000000000e-06 4.199647800282e-01
+ 6.880000000000e-06 4.200257592434e-01
+ 6.881000000000e-06 4.200867384587e-01
+ 6.882000000000e-06 4.201477176739e-01
+ 6.883000000000e-06 4.202086968891e-01
+ 6.884000000000e-06 4.202696761043e-01
+ 6.885000000000e-06 4.203306553195e-01
+ 6.886000000000e-06 4.203916345347e-01
+ 6.887000000000e-06 4.204526137500e-01
+ 6.888000000000e-06 4.205135929652e-01
+ 6.889000000000e-06 4.205745721804e-01
+ 6.890000000000e-06 4.206355513956e-01
+ 6.891000000000e-06 4.206965306108e-01
+ 6.892000000000e-06 4.207575098260e-01
+ 6.893000000000e-06 4.208184890413e-01
+ 6.894000000000e-06 4.208794682565e-01
+ 6.895000000000e-06 4.209404474717e-01
+ 6.896000000000e-06 4.210014266869e-01
+ 6.897000000000e-06 4.210624059021e-01
+ 6.898000000000e-06 4.211233851173e-01
+ 6.899000000000e-06 4.211843643326e-01
+ 6.900000000000e-06 4.212453435478e-01
+ 6.901000000000e-06 4.213063227630e-01
+ 6.902000000000e-06 4.213673019782e-01
+ 6.903000000000e-06 4.214282811934e-01
+ 6.904000000000e-06 4.214892604086e-01
+ 6.905000000000e-06 4.215502396239e-01
+ 6.906000000000e-06 4.216112188391e-01
+ 6.907000000000e-06 4.216721980543e-01
+ 6.908000000000e-06 4.217331772695e-01
+ 6.909000000000e-06 4.217941564847e-01
+ 6.910000000000e-06 4.218551356999e-01
+ 6.911000000000e-06 4.219161149152e-01
+ 6.912000000000e-06 4.219770941304e-01
+ 6.913000000000e-06 4.220380733456e-01
+ 6.914000000000e-06 4.220990525608e-01
+ 6.915000000000e-06 4.221600317760e-01
+ 6.916000000000e-06 4.222210109912e-01
+ 6.917000000000e-06 4.222819902065e-01
+ 6.918000000000e-06 4.223429694217e-01
+ 6.919000000000e-06 4.224039486369e-01
+ 6.920000000000e-06 4.224649278521e-01
+ 6.921000000000e-06 4.225259070673e-01
+ 6.922000000000e-06 4.225868862825e-01
+ 6.923000000000e-06 4.226478654978e-01
+ 6.924000000000e-06 4.227088447130e-01
+ 6.925000000000e-06 4.227698239282e-01
+ 6.926000000000e-06 4.228308031434e-01
+ 6.927000000000e-06 4.228917823586e-01
+ 6.928000000000e-06 4.229527615738e-01
+ 6.929000000000e-06 4.230137407891e-01
+ 6.930000000000e-06 4.230747200043e-01
+ 6.931000000000e-06 4.231356992195e-01
+ 6.932000000000e-06 4.231966784347e-01
+ 6.933000000000e-06 4.232576576499e-01
+ 6.934000000000e-06 4.233186368651e-01
+ 6.935000000000e-06 4.233796160804e-01
+ 6.936000000000e-06 4.234405952956e-01
+ 6.937000000000e-06 4.235015745108e-01
+ 6.938000000000e-06 4.235625537260e-01
+ 6.939000000000e-06 4.236235329412e-01
+ 6.940000000000e-06 4.236845121564e-01
+ 6.941000000000e-06 4.237454913716e-01
+ 6.942000000000e-06 4.238064705869e-01
+ 6.943000000000e-06 4.238674498021e-01
+ 6.944000000000e-06 4.239284290173e-01
+ 6.945000000000e-06 4.239894082325e-01
+ 6.946000000000e-06 4.240503874477e-01
+ 6.947000000000e-06 4.241113666629e-01
+ 6.948000000000e-06 4.241723458782e-01
+ 6.949000000000e-06 4.242333250934e-01
+ 6.950000000000e-06 4.242943043086e-01
+ 6.951000000000e-06 4.243552835238e-01
+ 6.952000000000e-06 4.244162627390e-01
+ 6.953000000000e-06 4.244772419542e-01
+ 6.954000000000e-06 4.245382211695e-01
+ 6.955000000000e-06 4.245992003847e-01
+ 6.956000000000e-06 4.246601795999e-01
+ 6.957000000000e-06 4.247211588151e-01
+ 6.958000000000e-06 4.247821380303e-01
+ 6.959000000000e-06 4.248431172455e-01
+ 6.960000000000e-06 4.249040964608e-01
+ 6.961000000000e-06 4.249650756760e-01
+ 6.962000000000e-06 4.250260548912e-01
+ 6.963000000000e-06 4.250870341064e-01
+ 6.964000000000e-06 4.251480133216e-01
+ 6.965000000000e-06 4.252089925368e-01
+ 6.966000000000e-06 4.252699717521e-01
+ 6.967000000000e-06 4.253309509673e-01
+ 6.968000000000e-06 4.253919301825e-01
+ 6.969000000000e-06 4.254529093977e-01
+ 6.970000000000e-06 4.255138886129e-01
+ 6.971000000000e-06 4.255748678281e-01
+ 6.972000000000e-06 4.256358470434e-01
+ 6.973000000000e-06 4.256968262586e-01
+ 6.974000000000e-06 4.257578054738e-01
+ 6.975000000000e-06 4.258187846890e-01
+ 6.976000000000e-06 4.258797639042e-01
+ 6.977000000000e-06 4.259407431194e-01
+ 6.978000000000e-06 4.260017223347e-01
+ 6.979000000000e-06 4.260627015499e-01
+ 6.980000000000e-06 4.261236807651e-01
+ 6.981000000000e-06 4.261846599803e-01
+ 6.982000000000e-06 4.262456391955e-01
+ 6.983000000000e-06 4.263066184107e-01
+ 6.984000000000e-06 4.263675976260e-01
+ 6.985000000000e-06 4.264285768412e-01
+ 6.986000000000e-06 4.264895560564e-01
+ 6.987000000000e-06 4.265505352716e-01
+ 6.988000000000e-06 4.266115144868e-01
+ 6.989000000000e-06 4.266724937020e-01
+ 6.990000000000e-06 4.267334729173e-01
+ 6.991000000000e-06 4.267944521325e-01
+ 6.992000000000e-06 4.268554313477e-01
+ 6.993000000000e-06 4.269164105629e-01
+ 6.994000000000e-06 4.269773897781e-01
+ 6.995000000000e-06 4.270383689933e-01
+ 6.996000000000e-06 4.270993482086e-01
+ 6.997000000000e-06 4.271603274238e-01
+ 6.998000000000e-06 4.272213066390e-01
+ 6.999000000000e-06 4.272822858542e-01
+ 7.000000000000e-06 4.273432650694e-01
+ 7.001000000000e-06 4.274042442846e-01
+ 7.002000000000e-06 4.274652234999e-01
+ 7.003000000000e-06 4.275262027151e-01
+ 7.004000000000e-06 4.275871819303e-01
+ 7.005000000000e-06 4.276481611455e-01
+ 7.006000000000e-06 4.277091403607e-01
+ 7.007000000000e-06 4.277701195759e-01
+ 7.008000000000e-06 4.278310987912e-01
+ 7.009000000000e-06 4.278920780064e-01
+ 7.010000000000e-06 4.279530572216e-01
+ 7.011000000000e-06 4.280140364368e-01
+ 7.012000000000e-06 4.280750156520e-01
+ 7.013000000000e-06 4.281359948672e-01
+ 7.014000000000e-06 4.281969740825e-01
+ 7.015000000000e-06 4.282579532977e-01
+ 7.016000000000e-06 4.283189325129e-01
+ 7.017000000000e-06 4.283799117281e-01
+ 7.018000000000e-06 4.284408909433e-01
+ 7.019000000000e-06 4.285018701585e-01
+ 7.020000000000e-06 4.285628493738e-01
+ 7.021000000000e-06 4.286238285890e-01
+ 7.022000000000e-06 4.286848078042e-01
+ 7.023000000000e-06 4.287457870194e-01
+ 7.024000000000e-06 4.288067662346e-01
+ 7.025000000000e-06 4.288677454498e-01
+ 7.026000000000e-06 4.289287246651e-01
+ 7.027000000000e-06 4.289897038803e-01
+ 7.028000000000e-06 4.290506830955e-01
+ 7.029000000000e-06 4.291116623107e-01
+ 7.030000000000e-06 4.291726415259e-01
+ 7.031000000000e-06 4.292336207411e-01
+ 7.032000000000e-06 4.292945999564e-01
+ 7.033000000000e-06 4.293555791716e-01
+ 7.034000000000e-06 4.294165583868e-01
+ 7.035000000000e-06 4.294775376020e-01
+ 7.036000000000e-06 4.295385168172e-01
+ 7.037000000000e-06 4.295994960324e-01
+ 7.038000000000e-06 4.296604752477e-01
+ 7.039000000000e-06 4.297214544629e-01
+ 7.040000000000e-06 4.297824336781e-01
+ 7.041000000000e-06 4.298434128933e-01
+ 7.042000000000e-06 4.299043921085e-01
+ 7.043000000000e-06 4.299653713237e-01
+ 7.044000000000e-06 4.300263505390e-01
+ 7.045000000000e-06 4.300873297542e-01
+ 7.046000000000e-06 4.301483089694e-01
+ 7.047000000000e-06 4.302092881846e-01
+ 7.048000000000e-06 4.302702673998e-01
+ 7.049000000000e-06 4.303312466150e-01
+ 7.050000000000e-06 4.303922258303e-01
+ 7.051000000000e-06 4.304532050455e-01
+ 7.052000000000e-06 4.305141842607e-01
+ 7.053000000000e-06 4.305751634759e-01
+ 7.054000000000e-06 4.306361426911e-01
+ 7.055000000000e-06 4.306971219063e-01
+ 7.056000000000e-06 4.307581011216e-01
+ 7.057000000000e-06 4.308190803368e-01
+ 7.058000000000e-06 4.308800595520e-01
+ 7.059000000000e-06 4.309410387672e-01
+ 7.060000000000e-06 4.310020179824e-01
+ 7.061000000000e-06 4.310629971976e-01
+ 7.062000000000e-06 4.311239764129e-01
+ 7.063000000000e-06 4.311849556281e-01
+ 7.064000000000e-06 4.312459348433e-01
+ 7.065000000000e-06 4.313069140585e-01
+ 7.066000000000e-06 4.313678932737e-01
+ 7.067000000000e-06 4.314288724889e-01
+ 7.068000000000e-06 4.314898517042e-01
+ 7.069000000000e-06 4.315508309194e-01
+ 7.070000000000e-06 4.316118101346e-01
+ 7.071000000000e-06 4.316727893498e-01
+ 7.072000000000e-06 4.317337685650e-01
+ 7.073000000000e-06 4.317947477802e-01
+ 7.074000000000e-06 4.318557269955e-01
+ 7.075000000000e-06 4.319167062107e-01
+ 7.076000000000e-06 4.319776854259e-01
+ 7.077000000000e-06 4.320386646411e-01
+ 7.078000000000e-06 4.320996438563e-01
+ 7.079000000000e-06 4.321606230715e-01
+ 7.080000000000e-06 4.322216022868e-01
+ 7.081000000000e-06 4.322825815020e-01
+ 7.082000000000e-06 4.323435607172e-01
+ 7.083000000000e-06 4.324045399324e-01
+ 7.084000000000e-06 4.324655191476e-01
+ 7.085000000000e-06 4.325264983628e-01
+ 7.086000000000e-06 4.325874775781e-01
+ 7.087000000000e-06 4.326484567933e-01
+ 7.088000000000e-06 4.327094360085e-01
+ 7.089000000000e-06 4.327704152237e-01
+ 7.090000000000e-06 4.328313944389e-01
+ 7.091000000000e-06 4.328923736541e-01
+ 7.092000000000e-06 4.329533528694e-01
+ 7.093000000000e-06 4.330143320846e-01
+ 7.094000000000e-06 4.330753112998e-01
+ 7.095000000000e-06 4.331362905150e-01
+ 7.096000000000e-06 4.331972697302e-01
+ 7.097000000000e-06 4.332582489454e-01
+ 7.098000000000e-06 4.333192281607e-01
+ 7.099000000000e-06 4.333802073759e-01
+ 7.100000000000e-06 4.334411865911e-01
+ 7.101000000000e-06 4.335021658063e-01
+ 7.102000000000e-06 4.335631450215e-01
+ 7.103000000000e-06 4.336241242367e-01
+ 7.104000000000e-06 4.336851034520e-01
+ 7.105000000000e-06 4.337460826672e-01
+ 7.106000000000e-06 4.338070618824e-01
+ 7.107000000000e-06 4.338680410976e-01
+ 7.108000000000e-06 4.339290203128e-01
+ 7.109000000000e-06 4.339899995280e-01
+ 7.110000000000e-06 4.340509787433e-01
+ 7.111000000000e-06 4.341119579585e-01
+ 7.112000000000e-06 4.341729371737e-01
+ 7.113000000000e-06 4.342339163889e-01
+ 7.114000000000e-06 4.342948956041e-01
+ 7.115000000000e-06 4.343558748193e-01
+ 7.116000000000e-06 4.344168540346e-01
+ 7.117000000000e-06 4.344778332498e-01
+ 7.118000000000e-06 4.345388124650e-01
+ 7.119000000000e-06 4.345997916802e-01
+ 7.120000000000e-06 4.346607708954e-01
+ 7.121000000000e-06 4.347217501106e-01
+ 7.122000000000e-06 4.347827293259e-01
+ 7.123000000000e-06 4.348437085411e-01
+ 7.124000000000e-06 4.349046877563e-01
+ 7.125000000000e-06 4.349656669715e-01
+ 7.126000000000e-06 4.350266461867e-01
+ 7.127000000000e-06 4.350876254019e-01
+ 7.128000000000e-06 4.351486046172e-01
+ 7.129000000000e-06 4.352095838324e-01
+ 7.130000000000e-06 4.352705630476e-01
+ 7.131000000000e-06 4.353315422628e-01
+ 7.132000000000e-06 4.353925214780e-01
+ 7.133000000000e-06 4.354535006932e-01
+ 7.134000000000e-06 4.355144799085e-01
+ 7.135000000000e-06 4.355754591237e-01
+ 7.136000000000e-06 4.356364383389e-01
+ 7.137000000000e-06 4.356974175541e-01
+ 7.138000000000e-06 4.357583967693e-01
+ 7.139000000000e-06 4.358193759845e-01
+ 7.140000000000e-06 4.358803551998e-01
+ 7.141000000000e-06 4.359413344150e-01
+ 7.142000000000e-06 4.360023136302e-01
+ 7.143000000000e-06 4.360632928454e-01
+ 7.144000000000e-06 4.361242720606e-01
+ 7.145000000000e-06 4.361852512758e-01
+ 7.146000000000e-06 4.362462304911e-01
+ 7.147000000000e-06 4.363072097063e-01
+ 7.148000000000e-06 4.363681889215e-01
+ 7.149000000000e-06 4.364291681367e-01
+ 7.150000000000e-06 4.364901473519e-01
+ 7.151000000000e-06 4.365511265671e-01
+ 7.152000000000e-06 4.366121057824e-01
+ 7.153000000000e-06 4.366730849976e-01
+ 7.154000000000e-06 4.367340642128e-01
+ 7.155000000000e-06 4.367950434280e-01
+ 7.156000000000e-06 4.368560226432e-01
+ 7.157000000000e-06 4.369170018584e-01
+ 7.158000000000e-06 4.369779810737e-01
+ 7.159000000000e-06 4.370389602889e-01
+ 7.160000000000e-06 4.370999395041e-01
+ 7.161000000000e-06 4.371609187193e-01
+ 7.162000000000e-06 4.372218979345e-01
+ 7.163000000000e-06 4.372828771497e-01
+ 7.164000000000e-06 4.373438563650e-01
+ 7.165000000000e-06 4.374048355802e-01
+ 7.166000000000e-06 4.374658147954e-01
+ 7.167000000000e-06 4.375267940106e-01
+ 7.168000000000e-06 4.375877732258e-01
+ 7.169000000000e-06 4.376487524410e-01
+ 7.170000000000e-06 4.377097316562e-01
+ 7.171000000000e-06 4.377707108715e-01
+ 7.172000000000e-06 4.378316900867e-01
+ 7.173000000000e-06 4.378926693019e-01
+ 7.174000000000e-06 4.379536485171e-01
+ 7.175000000000e-06 4.380146277323e-01
+ 7.176000000000e-06 4.380756069475e-01
+ 7.177000000000e-06 4.381365861628e-01
+ 7.178000000000e-06 4.381975653780e-01
+ 7.179000000000e-06 4.382585445932e-01
+ 7.180000000000e-06 4.383195238084e-01
+ 7.181000000000e-06 4.383805030236e-01
+ 7.182000000000e-06 4.384414822388e-01
+ 7.183000000000e-06 4.385024614541e-01
+ 7.184000000000e-06 4.385634406693e-01
+ 7.185000000000e-06 4.386244198845e-01
+ 7.186000000000e-06 4.386853990997e-01
+ 7.187000000000e-06 4.387463783149e-01
+ 7.188000000000e-06 4.388073575301e-01
+ 7.189000000000e-06 4.388683367454e-01
+ 7.190000000000e-06 4.389293159606e-01
+ 7.191000000000e-06 4.389902951758e-01
+ 7.192000000000e-06 4.390512743910e-01
+ 7.193000000000e-06 4.391122536062e-01
+ 7.194000000000e-06 4.391732328214e-01
+ 7.195000000000e-06 4.392342120367e-01
+ 7.196000000000e-06 4.392951912519e-01
+ 7.197000000000e-06 4.393561704671e-01
+ 7.198000000000e-06 4.394171496823e-01
+ 7.199000000000e-06 4.394781288975e-01
+ 7.200000000000e-06 4.395391081127e-01
+ 7.201000000000e-06 4.396000873280e-01
+ 7.202000000000e-06 4.396610665432e-01
+ 7.203000000000e-06 4.397220457584e-01
+ 7.204000000000e-06 4.397830249736e-01
+ 7.205000000000e-06 4.398440041888e-01
+ 7.206000000000e-06 4.399049834040e-01
+ 7.207000000000e-06 4.399659626193e-01
+ 7.208000000000e-06 4.400269418345e-01
+ 7.209000000000e-06 4.400879210497e-01
+ 7.210000000000e-06 4.401489002649e-01
+ 7.211000000000e-06 4.402098794801e-01
+ 7.212000000000e-06 4.402708586953e-01
+ 7.213000000000e-06 4.403318379106e-01
+ 7.214000000000e-06 4.403928171258e-01
+ 7.215000000000e-06 4.404537963410e-01
+ 7.216000000000e-06 4.405147755562e-01
+ 7.217000000000e-06 4.405757547714e-01
+ 7.218000000000e-06 4.406367339866e-01
+ 7.219000000000e-06 4.406977132019e-01
+ 7.220000000000e-06 4.407586924171e-01
+ 7.221000000000e-06 4.408196716323e-01
+ 7.222000000000e-06 4.408806508475e-01
+ 7.223000000000e-06 4.409416300627e-01
+ 7.224000000000e-06 4.410026092779e-01
+ 7.225000000000e-06 4.410635884932e-01
+ 7.226000000000e-06 4.411245677084e-01
+ 7.227000000000e-06 4.411855469236e-01
+ 7.228000000000e-06 4.412465261388e-01
+ 7.229000000000e-06 4.413075053540e-01
+ 7.230000000000e-06 4.413684845692e-01
+ 7.231000000000e-06 4.414294637845e-01
+ 7.232000000000e-06 4.414904429997e-01
+ 7.233000000000e-06 4.415514222149e-01
+ 7.234000000000e-06 4.416124014301e-01
+ 7.235000000000e-06 4.416733806453e-01
+ 7.236000000000e-06 4.417343598605e-01
+ 7.237000000000e-06 4.417953390758e-01
+ 7.238000000000e-06 4.418563182910e-01
+ 7.239000000000e-06 4.419172975062e-01
+ 7.240000000000e-06 4.419782767214e-01
+ 7.241000000000e-06 4.420392559366e-01
+ 7.242000000000e-06 4.421002351518e-01
+ 7.243000000000e-06 4.421612143671e-01
+ 7.244000000000e-06 4.422221935823e-01
+ 7.245000000000e-06 4.422831727975e-01
+ 7.246000000000e-06 4.423441520127e-01
+ 7.247000000000e-06 4.424051312279e-01
+ 7.248000000000e-06 4.424661104431e-01
+ 7.249000000000e-06 4.425270896584e-01
+ 7.250000000000e-06 4.425880688736e-01
+ 7.251000000000e-06 4.426490480888e-01
+ 7.252000000000e-06 4.427100273040e-01
+ 7.253000000000e-06 4.427710065192e-01
+ 7.254000000000e-06 4.428319857344e-01
+ 7.255000000000e-06 4.428929649497e-01
+ 7.256000000000e-06 4.429539441649e-01
+ 7.257000000000e-06 4.430149233801e-01
+ 7.258000000000e-06 4.430759025953e-01
+ 7.259000000000e-06 4.431368818105e-01
+ 7.260000000000e-06 4.431978610257e-01
+ 7.261000000000e-06 4.432588402410e-01
+ 7.262000000000e-06 4.433198194562e-01
+ 7.263000000000e-06 4.433807986714e-01
+ 7.264000000000e-06 4.434417778866e-01
+ 7.265000000000e-06 4.435027571018e-01
+ 7.266000000000e-06 4.435637363170e-01
+ 7.267000000000e-06 4.436247155323e-01
+ 7.268000000000e-06 4.436856947475e-01
+ 7.269000000000e-06 4.437466739627e-01
+ 7.270000000000e-06 4.438076531779e-01
+ 7.271000000000e-06 4.438686323931e-01
+ 7.272000000000e-06 4.439296116083e-01
+ 7.273000000000e-06 4.439905908236e-01
+ 7.274000000000e-06 4.440515700388e-01
+ 7.275000000000e-06 4.441125492540e-01
+ 7.276000000000e-06 4.441735284692e-01
+ 7.277000000000e-06 4.442345076844e-01
+ 7.278000000000e-06 4.442954868996e-01
+ 7.279000000000e-06 4.443564661149e-01
+ 7.280000000000e-06 4.444174453301e-01
+ 7.281000000000e-06 4.444784245453e-01
+ 7.282000000000e-06 4.445394037605e-01
+ 7.283000000000e-06 4.446003829757e-01
+ 7.284000000000e-06 4.446613621909e-01
+ 7.285000000000e-06 4.447223414062e-01
+ 7.286000000000e-06 4.447833206214e-01
+ 7.287000000000e-06 4.448442998366e-01
+ 7.288000000000e-06 4.449052790518e-01
+ 7.289000000000e-06 4.449662582670e-01
+ 7.290000000000e-06 4.450272374822e-01
+ 7.291000000000e-06 4.450882166975e-01
+ 7.292000000000e-06 4.451491959127e-01
+ 7.293000000000e-06 4.452101751279e-01
+ 7.294000000000e-06 4.452711543431e-01
+ 7.295000000000e-06 4.453321335583e-01
+ 7.296000000000e-06 4.453931127735e-01
+ 7.297000000000e-06 4.454540919888e-01
+ 7.298000000000e-06 4.455150712040e-01
+ 7.299000000000e-06 4.455760504192e-01
+ 7.300000000000e-06 4.456370296344e-01
+ 7.301000000000e-06 4.456980088496e-01
+ 7.302000000000e-06 4.457589880648e-01
+ 7.303000000000e-06 4.458199672801e-01
+ 7.304000000000e-06 4.458809464953e-01
+ 7.305000000000e-06 4.459419257105e-01
+ 7.306000000000e-06 4.460029049257e-01
+ 7.307000000000e-06 4.460638841409e-01
+ 7.308000000000e-06 4.461248633561e-01
+ 7.309000000000e-06 4.461858425714e-01
+ 7.310000000000e-06 4.462468217866e-01
+ 7.311000000000e-06 4.463078010018e-01
+ 7.312000000000e-06 4.463687802170e-01
+ 7.313000000000e-06 4.464297594322e-01
+ 7.314000000000e-06 4.464907386474e-01
+ 7.315000000000e-06 4.465517178627e-01
+ 7.316000000000e-06 4.466126970779e-01
+ 7.317000000000e-06 4.466736762931e-01
+ 7.318000000000e-06 4.467346555083e-01
+ 7.319000000000e-06 4.467956347235e-01
+ 7.320000000000e-06 4.468566139387e-01
+ 7.321000000000e-06 4.469175931540e-01
+ 7.322000000000e-06 4.469785723692e-01
+ 7.323000000000e-06 4.470395515844e-01
+ 7.324000000000e-06 4.471005307996e-01
+ 7.325000000000e-06 4.471615100148e-01
+ 7.326000000000e-06 4.472224892300e-01
+ 7.327000000000e-06 4.472834684453e-01
+ 7.328000000000e-06 4.473444476605e-01
+ 7.329000000000e-06 4.474054268757e-01
+ 7.330000000000e-06 4.474664060909e-01
+ 7.331000000000e-06 4.475273853061e-01
+ 7.332000000000e-06 4.475883645213e-01
+ 7.333000000000e-06 4.476493437366e-01
+ 7.334000000000e-06 4.477103229518e-01
+ 7.335000000000e-06 4.477713021670e-01
+ 7.336000000000e-06 4.478322813822e-01
+ 7.337000000000e-06 4.478932605974e-01
+ 7.338000000000e-06 4.479542398126e-01
+ 7.339000000000e-06 4.480152190279e-01
+ 7.340000000000e-06 4.480761982431e-01
+ 7.341000000000e-06 4.481371774583e-01
+ 7.342000000000e-06 4.481981566735e-01
+ 7.343000000000e-06 4.482591358887e-01
+ 7.344000000000e-06 4.483201151039e-01
+ 7.345000000000e-06 4.483810943192e-01
+ 7.346000000000e-06 4.484420735344e-01
+ 7.347000000000e-06 4.485030527496e-01
+ 7.348000000000e-06 4.485640319648e-01
+ 7.349000000000e-06 4.486250111800e-01
+ 7.350000000000e-06 4.486859903952e-01
+ 7.351000000000e-06 4.487469696105e-01
+ 7.352000000000e-06 4.488079488257e-01
+ 7.353000000000e-06 4.488689280409e-01
+ 7.354000000000e-06 4.489299072561e-01
+ 7.355000000000e-06 4.489908864713e-01
+ 7.356000000000e-06 4.490518656865e-01
+ 7.357000000000e-06 4.491128449018e-01
+ 7.358000000000e-06 4.491738241170e-01
+ 7.359000000000e-06 4.492348033322e-01
+ 7.360000000000e-06 4.492957825474e-01
+ 7.361000000000e-06 4.493567617626e-01
+ 7.362000000000e-06 4.494177409778e-01
+ 7.363000000000e-06 4.494787201931e-01
+ 7.364000000000e-06 4.495396994083e-01
+ 7.365000000000e-06 4.496006786235e-01
+ 7.366000000000e-06 4.496616578387e-01
+ 7.367000000000e-06 4.497226370539e-01
+ 7.368000000000e-06 4.497836162691e-01
+ 7.369000000000e-06 4.498445954844e-01
+ 7.370000000000e-06 4.499055746996e-01
+ 7.371000000000e-06 4.499665539148e-01
+ 7.372000000000e-06 4.500275331300e-01
+ 7.373000000000e-06 4.500885123452e-01
+ 7.374000000000e-06 4.501494915604e-01
+ 7.375000000000e-06 4.502104707757e-01
+ 7.376000000000e-06 4.502714499909e-01
+ 7.377000000000e-06 4.503324292061e-01
+ 7.378000000000e-06 4.503934084213e-01
+ 7.379000000000e-06 4.504543876365e-01
+ 7.380000000000e-06 4.505153668517e-01
+ 7.381000000000e-06 4.505763460670e-01
+ 7.382000000000e-06 4.506373252822e-01
+ 7.383000000000e-06 4.506983044974e-01
+ 7.384000000000e-06 4.507592837126e-01
+ 7.385000000000e-06 4.508202629278e-01
+ 7.386000000000e-06 4.508812421430e-01
+ 7.387000000000e-06 4.509422213583e-01
+ 7.388000000000e-06 4.510032005735e-01
+ 7.389000000000e-06 4.510641797887e-01
+ 7.390000000000e-06 4.511251590039e-01
+ 7.391000000000e-06 4.511861382191e-01
+ 7.392000000000e-06 4.512471174343e-01
+ 7.393000000000e-06 4.513080966496e-01
+ 7.394000000000e-06 4.513690758648e-01
+ 7.395000000000e-06 4.514300550800e-01
+ 7.396000000000e-06 4.514910342952e-01
+ 7.397000000000e-06 4.515520135104e-01
+ 7.398000000000e-06 4.516129927256e-01
+ 7.399000000000e-06 4.516739719408e-01
+ 7.400000000000e-06 4.517349511561e-01
+ 7.401000000000e-06 4.517959303713e-01
+ 7.402000000000e-06 4.518569095865e-01
+ 7.403000000000e-06 4.519178888017e-01
+ 7.404000000000e-06 4.519788680169e-01
+ 7.405000000000e-06 4.520398472321e-01
+ 7.406000000000e-06 4.521008264474e-01
+ 7.407000000000e-06 4.521618056626e-01
+ 7.408000000000e-06 4.522227848778e-01
+ 7.409000000000e-06 4.522837640930e-01
+ 7.410000000000e-06 4.523447433082e-01
+ 7.411000000000e-06 4.524057225234e-01
+ 7.412000000000e-06 4.524667017387e-01
+ 7.413000000000e-06 4.525276809539e-01
+ 7.414000000000e-06 4.525886601691e-01
+ 7.415000000000e-06 4.526496393843e-01
+ 7.416000000000e-06 4.527106185995e-01
+ 7.417000000000e-06 4.527715978147e-01
+ 7.418000000000e-06 4.528325770300e-01
+ 7.419000000000e-06 4.528935562452e-01
+ 7.420000000000e-06 4.529545354604e-01
+ 7.421000000000e-06 4.530155146756e-01
+ 7.422000000000e-06 4.530764938908e-01
+ 7.423000000000e-06 4.531374731060e-01
+ 7.424000000000e-06 4.531984523213e-01
+ 7.425000000000e-06 4.532594315365e-01
+ 7.426000000000e-06 4.533204107517e-01
+ 7.427000000000e-06 4.533813899669e-01
+ 7.428000000000e-06 4.534423691821e-01
+ 7.429000000000e-06 4.535033483973e-01
+ 7.430000000000e-06 4.535643276126e-01
+ 7.431000000000e-06 4.536253068278e-01
+ 7.432000000000e-06 4.536862860430e-01
+ 7.433000000000e-06 4.537472652582e-01
+ 7.434000000000e-06 4.538082444734e-01
+ 7.435000000000e-06 4.538692236886e-01
+ 7.436000000000e-06 4.539302029039e-01
+ 7.437000000000e-06 4.539911821191e-01
+ 7.438000000000e-06 4.540521613343e-01
+ 7.439000000000e-06 4.541131405495e-01
+ 7.440000000000e-06 4.541741197647e-01
+ 7.441000000000e-06 4.542350989799e-01
+ 7.442000000000e-06 4.542960781952e-01
+ 7.443000000000e-06 4.543570574104e-01
+ 7.444000000000e-06 4.544180366256e-01
+ 7.445000000000e-06 4.544790158408e-01
+ 7.446000000000e-06 4.545399950560e-01
+ 7.447000000000e-06 4.546009742712e-01
+ 7.448000000000e-06 4.546619534865e-01
+ 7.449000000000e-06 4.547229327017e-01
+ 7.450000000000e-06 4.547839119169e-01
+ 7.451000000000e-06 4.548448911321e-01
+ 7.452000000000e-06 4.549058703473e-01
+ 7.453000000000e-06 4.549668495625e-01
+ 7.454000000000e-06 4.550278287778e-01
+ 7.455000000000e-06 4.550888079930e-01
+ 7.456000000000e-06 4.551497872082e-01
+ 7.457000000000e-06 4.552107664234e-01
+ 7.458000000000e-06 4.552717456386e-01
+ 7.459000000000e-06 4.553327248538e-01
+ 7.460000000000e-06 4.553937040691e-01
+ 7.461000000000e-06 4.554546832843e-01
+ 7.462000000000e-06 4.555156624995e-01
+ 7.463000000000e-06 4.555766417147e-01
+ 7.464000000000e-06 4.556376209299e-01
+ 7.465000000000e-06 4.556986001451e-01
+ 7.466000000000e-06 4.557595793604e-01
+ 7.467000000000e-06 4.558205585756e-01
+ 7.468000000000e-06 4.558815377908e-01
+ 7.469000000000e-06 4.559425170060e-01
+ 7.470000000000e-06 4.560034962212e-01
+ 7.471000000000e-06 4.560644754364e-01
+ 7.472000000000e-06 4.561254546517e-01
+ 7.473000000000e-06 4.561864338669e-01
+ 7.474000000000e-06 4.562474130821e-01
+ 7.475000000000e-06 4.563083922973e-01
+ 7.476000000000e-06 4.563693715125e-01
+ 7.477000000000e-06 4.564303507277e-01
+ 7.478000000000e-06 4.564913299430e-01
+ 7.479000000000e-06 4.565523091582e-01
+ 7.480000000000e-06 4.566132883734e-01
+ 7.481000000000e-06 4.566742675886e-01
+ 7.482000000000e-06 4.567352468038e-01
+ 7.483000000000e-06 4.567962260190e-01
+ 7.484000000000e-06 4.568572052343e-01
+ 7.485000000000e-06 4.569181844495e-01
+ 7.486000000000e-06 4.569791636647e-01
+ 7.487000000000e-06 4.570401428799e-01
+ 7.488000000000e-06 4.571011220951e-01
+ 7.489000000000e-06 4.571621013103e-01
+ 7.490000000000e-06 4.572230805256e-01
+ 7.491000000000e-06 4.572840597408e-01
+ 7.492000000000e-06 4.573450389560e-01
+ 7.493000000000e-06 4.574060181712e-01
+ 7.494000000000e-06 4.574669973864e-01
+ 7.495000000000e-06 4.575279766016e-01
+ 7.496000000000e-06 4.575889558169e-01
+ 7.497000000000e-06 4.576499350321e-01
+ 7.498000000000e-06 4.577109142473e-01
+ 7.499000000000e-06 4.577718934625e-01
+ 7.500000000000e-06 4.578328726777e-01
+ 7.501000000000e-06 4.578938518929e-01
+ 7.502000000000e-06 4.579548311082e-01
+ 7.503000000000e-06 4.580158103234e-01
+ 7.504000000000e-06 4.580767895386e-01
+ 7.505000000000e-06 4.581377687538e-01
+ 7.506000000000e-06 4.581987479690e-01
+ 7.507000000000e-06 4.582597271842e-01
+ 7.508000000000e-06 4.583207063995e-01
+ 7.509000000000e-06 4.583816856147e-01
+ 7.510000000000e-06 4.584426648299e-01
+ 7.511000000000e-06 4.585036440451e-01
+ 7.512000000000e-06 4.585646232603e-01
+ 7.513000000000e-06 4.586256024755e-01
+ 7.514000000000e-06 4.586865816908e-01
+ 7.515000000000e-06 4.587475609060e-01
+ 7.516000000000e-06 4.588085401212e-01
+ 7.517000000000e-06 4.588695193364e-01
+ 7.518000000000e-06 4.589304985516e-01
+ 7.519000000000e-06 4.589914777668e-01
+ 7.520000000000e-06 4.590524569821e-01
+ 7.521000000000e-06 4.591134361973e-01
+ 7.522000000000e-06 4.591744154125e-01
+ 7.523000000000e-06 4.592353946277e-01
+ 7.524000000000e-06 4.592963738429e-01
+ 7.525000000000e-06 4.593573530581e-01
+ 7.526000000000e-06 4.594183322734e-01
+ 7.527000000000e-06 4.594793114886e-01
+ 7.528000000000e-06 4.595402907038e-01
+ 7.529000000000e-06 4.596012699190e-01
+ 7.530000000000e-06 4.596622491342e-01
+ 7.531000000000e-06 4.597232283494e-01
+ 7.532000000000e-06 4.597842075647e-01
+ 7.533000000000e-06 4.598451867799e-01
+ 7.534000000000e-06 4.599061659951e-01
+ 7.535000000000e-06 4.599671452103e-01
+ 7.536000000000e-06 4.600281244255e-01
+ 7.537000000000e-06 4.600891036407e-01
+ 7.538000000000e-06 4.601500828560e-01
+ 7.539000000000e-06 4.602110620712e-01
+ 7.540000000000e-06 4.602720412864e-01
+ 7.541000000000e-06 4.603330205016e-01
+ 7.542000000000e-06 4.603939997168e-01
+ 7.543000000000e-06 4.604549789320e-01
+ 7.544000000000e-06 4.605159581473e-01
+ 7.545000000000e-06 4.605769373625e-01
+ 7.546000000000e-06 4.606379165777e-01
+ 7.547000000000e-06 4.606988957929e-01
+ 7.548000000000e-06 4.607598750081e-01
+ 7.549000000000e-06 4.608208542233e-01
+ 7.550000000000e-06 4.608818334386e-01
+ 7.551000000000e-06 4.609428126538e-01
+ 7.552000000000e-06 4.610037918690e-01
+ 7.553000000000e-06 4.610647710842e-01
+ 7.554000000000e-06 4.611257502994e-01
+ 7.555000000000e-06 4.611867295146e-01
+ 7.556000000000e-06 4.612477087299e-01
+ 7.557000000000e-06 4.613086879451e-01
+ 7.558000000000e-06 4.613696671603e-01
+ 7.559000000000e-06 4.614306463755e-01
+ 7.560000000000e-06 4.614916255907e-01
+ 7.561000000000e-06 4.615526048059e-01
+ 7.562000000000e-06 4.616135840212e-01
+ 7.563000000000e-06 4.616745632364e-01
+ 7.564000000000e-06 4.617355424516e-01
+ 7.565000000000e-06 4.617965216668e-01
+ 7.566000000000e-06 4.618575008820e-01
+ 7.567000000000e-06 4.619184800972e-01
+ 7.568000000000e-06 4.619794593125e-01
+ 7.569000000000e-06 4.620404385277e-01
+ 7.570000000000e-06 4.621014177429e-01
+ 7.571000000000e-06 4.621623969581e-01
+ 7.572000000000e-06 4.622233761733e-01
+ 7.573000000000e-06 4.622843553885e-01
+ 7.574000000000e-06 4.623453346038e-01
+ 7.575000000000e-06 4.624063138190e-01
+ 7.576000000000e-06 4.624672930342e-01
+ 7.577000000000e-06 4.625282722494e-01
+ 7.578000000000e-06 4.625892514646e-01
+ 7.579000000000e-06 4.626502306798e-01
+ 7.580000000000e-06 4.627112098951e-01
+ 7.581000000000e-06 4.627721891103e-01
+ 7.582000000000e-06 4.628331683255e-01
+ 7.583000000000e-06 4.628941475407e-01
+ 7.584000000000e-06 4.629551267559e-01
+ 7.585000000000e-06 4.630161059711e-01
+ 7.586000000000e-06 4.630770851864e-01
+ 7.587000000000e-06 4.631380644016e-01
+ 7.588000000000e-06 4.631990436168e-01
+ 7.589000000000e-06 4.632600228320e-01
+ 7.590000000000e-06 4.633210020472e-01
+ 7.591000000000e-06 4.633819812624e-01
+ 7.592000000000e-06 4.634429604777e-01
+ 7.593000000000e-06 4.635039396929e-01
+ 7.594000000000e-06 4.635649189081e-01
+ 7.595000000000e-06 4.636258981233e-01
+ 7.596000000000e-06 4.636868773385e-01
+ 7.597000000000e-06 4.637478565537e-01
+ 7.598000000000e-06 4.638088357690e-01
+ 7.599000000000e-06 4.638698149842e-01
+ 7.600000000000e-06 4.639307941994e-01
+ 7.601000000000e-06 4.639917734146e-01
+ 7.602000000000e-06 4.640527526298e-01
+ 7.603000000000e-06 4.641137318450e-01
+ 7.604000000000e-06 4.641747110603e-01
+ 7.605000000000e-06 4.642356902755e-01
+ 7.606000000000e-06 4.642966694907e-01
+ 7.607000000000e-06 4.643576487059e-01
+ 7.608000000000e-06 4.644186279211e-01
+ 7.609000000000e-06 4.644796071363e-01
+ 7.610000000000e-06 4.645405863516e-01
+ 7.611000000000e-06 4.646015655668e-01
+ 7.612000000000e-06 4.646625447820e-01
+ 7.613000000000e-06 4.647235239972e-01
+ 7.614000000000e-06 4.647845032124e-01
+ 7.615000000000e-06 4.648454824276e-01
+ 7.616000000000e-06 4.649064616429e-01
+ 7.617000000000e-06 4.649674408581e-01
+ 7.618000000000e-06 4.650284200733e-01
+ 7.619000000000e-06 4.650893992885e-01
+ 7.620000000000e-06 4.651503785037e-01
+ 7.621000000000e-06 4.652113577189e-01
+ 7.622000000000e-06 4.652723369342e-01
+ 7.623000000000e-06 4.653333161494e-01
+ 7.624000000000e-06 4.653942953646e-01
+ 7.625000000000e-06 4.654552745798e-01
+ 7.626000000000e-06 4.655162537950e-01
+ 7.627000000000e-06 4.655772330102e-01
+ 7.628000000000e-06 4.656382122254e-01
+ 7.629000000000e-06 4.656991914407e-01
+ 7.630000000000e-06 4.657601706559e-01
+ 7.631000000000e-06 4.658211498711e-01
+ 7.632000000000e-06 4.658821290863e-01
+ 7.633000000000e-06 4.659431083015e-01
+ 7.634000000000e-06 4.660040875167e-01
+ 7.635000000000e-06 4.660650667320e-01
+ 7.636000000000e-06 4.661260459472e-01
+ 7.637000000000e-06 4.661870251624e-01
+ 7.638000000000e-06 4.662480043776e-01
+ 7.639000000000e-06 4.663089835928e-01
+ 7.640000000000e-06 4.663699628080e-01
+ 7.641000000000e-06 4.664309420233e-01
+ 7.642000000000e-06 4.664919212385e-01
+ 7.643000000000e-06 4.665529004537e-01
+ 7.644000000000e-06 4.666138796689e-01
+ 7.645000000000e-06 4.666748588841e-01
+ 7.646000000000e-06 4.667358380993e-01
+ 7.647000000000e-06 4.667968173146e-01
+ 7.648000000000e-06 4.668577965298e-01
+ 7.649000000000e-06 4.669187757450e-01
+ 7.650000000000e-06 4.669797549602e-01
+ 7.651000000000e-06 4.670407341754e-01
+ 7.652000000000e-06 4.671017133906e-01
+ 7.653000000000e-06 4.671626926059e-01
+ 7.654000000000e-06 4.672236718211e-01
+ 7.655000000000e-06 4.672846510363e-01
+ 7.656000000000e-06 4.673456302515e-01
+ 7.657000000000e-06 4.674066094667e-01
+ 7.658000000000e-06 4.674675886819e-01
+ 7.659000000000e-06 4.675285678972e-01
+ 7.660000000000e-06 4.675895471124e-01
+ 7.661000000000e-06 4.676505263276e-01
+ 7.662000000000e-06 4.677115055428e-01
+ 7.663000000000e-06 4.677724847580e-01
+ 7.664000000000e-06 4.678334639732e-01
+ 7.665000000000e-06 4.678944431885e-01
+ 7.666000000000e-06 4.679554224037e-01
+ 7.667000000000e-06 4.680164016189e-01
+ 7.668000000000e-06 4.680773808341e-01
+ 7.669000000000e-06 4.681383600493e-01
+ 7.670000000000e-06 4.681993392645e-01
+ 7.671000000000e-06 4.682603184798e-01
+ 7.672000000000e-06 4.683212976950e-01
+ 7.673000000000e-06 4.683822769102e-01
+ 7.674000000000e-06 4.684432561254e-01
+ 7.675000000000e-06 4.685042353406e-01
+ 7.676000000000e-06 4.685652145558e-01
+ 7.677000000000e-06 4.686261937711e-01
+ 7.678000000000e-06 4.686871729863e-01
+ 7.679000000000e-06 4.687481522015e-01
+ 7.680000000000e-06 4.688091314167e-01
+ 7.681000000000e-06 4.688701106319e-01
+ 7.682000000000e-06 4.689310898471e-01
+ 7.683000000000e-06 4.689920690624e-01
+ 7.684000000000e-06 4.690530482776e-01
+ 7.685000000000e-06 4.691140274928e-01
+ 7.686000000000e-06 4.691750067080e-01
+ 7.687000000000e-06 4.692359859232e-01
+ 7.688000000000e-06 4.692969651384e-01
+ 7.689000000000e-06 4.693579443537e-01
+ 7.690000000000e-06 4.694189235689e-01
+ 7.691000000000e-06 4.694799027841e-01
+ 7.692000000000e-06 4.695408819993e-01
+ 7.693000000000e-06 4.696018612145e-01
+ 7.694000000000e-06 4.696628404297e-01
+ 7.695000000000e-06 4.697238196450e-01
+ 7.696000000000e-06 4.697847988602e-01
+ 7.697000000000e-06 4.698457780754e-01
+ 7.698000000000e-06 4.699067572906e-01
+ 7.699000000000e-06 4.699677365058e-01
+ 7.700000000000e-06 4.700287157210e-01
+ 7.701000000000e-06 4.700896949363e-01
+ 7.702000000000e-06 4.701506741515e-01
+ 7.703000000000e-06 4.702116533667e-01
+ 7.704000000000e-06 4.702726325819e-01
+ 7.705000000000e-06 4.703336117971e-01
+ 7.706000000000e-06 4.703945910123e-01
+ 7.707000000000e-06 4.704555702276e-01
+ 7.708000000000e-06 4.705165494428e-01
+ 7.709000000000e-06 4.705775286580e-01
+ 7.710000000000e-06 4.706385078732e-01
+ 7.711000000000e-06 4.706994870884e-01
+ 7.712000000000e-06 4.707604663036e-01
+ 7.713000000000e-06 4.708214455189e-01
+ 7.714000000000e-06 4.708824247341e-01
+ 7.715000000000e-06 4.709434039493e-01
+ 7.716000000000e-06 4.710043831645e-01
+ 7.717000000000e-06 4.710653623797e-01
+ 7.718000000000e-06 4.711263415949e-01
+ 7.719000000000e-06 4.711873208102e-01
+ 7.720000000000e-06 4.712483000254e-01
+ 7.721000000000e-06 4.713092792406e-01
+ 7.722000000000e-06 4.713702584558e-01
+ 7.723000000000e-06 4.714312376710e-01
+ 7.724000000000e-06 4.714922168862e-01
+ 7.725000000000e-06 4.715531961015e-01
+ 7.726000000000e-06 4.716141753167e-01
+ 7.727000000000e-06 4.716751545319e-01
+ 7.728000000000e-06 4.717361337471e-01
+ 7.729000000000e-06 4.717971129623e-01
+ 7.730000000000e-06 4.718580921775e-01
+ 7.731000000000e-06 4.719190713928e-01
+ 7.732000000000e-06 4.719800506080e-01
+ 7.733000000000e-06 4.720410298232e-01
+ 7.734000000000e-06 4.721020090384e-01
+ 7.735000000000e-06 4.721629882536e-01
+ 7.736000000000e-06 4.722239674688e-01
+ 7.737000000000e-06 4.722849466841e-01
+ 7.738000000000e-06 4.723459258993e-01
+ 7.739000000000e-06 4.724069051145e-01
+ 7.740000000000e-06 4.724678843297e-01
+ 7.741000000000e-06 4.725288635449e-01
+ 7.742000000000e-06 4.725898427601e-01
+ 7.743000000000e-06 4.726508219754e-01
+ 7.744000000000e-06 4.727118011906e-01
+ 7.745000000000e-06 4.727727804058e-01
+ 7.746000000000e-06 4.728337596210e-01
+ 7.747000000000e-06 4.728947388362e-01
+ 7.748000000000e-06 4.729557180514e-01
+ 7.749000000000e-06 4.730166972667e-01
+ 7.750000000000e-06 4.730776764819e-01
+ 7.751000000000e-06 4.731386556971e-01
+ 7.752000000000e-06 4.731996349123e-01
+ 7.753000000000e-06 4.732606141275e-01
+ 7.754000000000e-06 4.733215933427e-01
+ 7.755000000000e-06 4.733825725580e-01
+ 7.756000000000e-06 4.734435517732e-01
+ 7.757000000000e-06 4.735045309884e-01
+ 7.758000000000e-06 4.735655102036e-01
+ 7.759000000000e-06 4.736264894188e-01
+ 7.760000000000e-06 4.736874686340e-01
+ 7.761000000000e-06 4.737484478493e-01
+ 7.762000000000e-06 4.738094270645e-01
+ 7.763000000000e-06 4.738704062797e-01
+ 7.764000000000e-06 4.739313854949e-01
+ 7.765000000000e-06 4.739923647101e-01
+ 7.766000000000e-06 4.740533439253e-01
+ 7.767000000000e-06 4.741143231406e-01
+ 7.768000000000e-06 4.741753023558e-01
+ 7.769000000000e-06 4.742362815710e-01
+ 7.770000000000e-06 4.742972607862e-01
+ 7.771000000000e-06 4.743582400014e-01
+ 7.772000000000e-06 4.744192192166e-01
+ 7.773000000000e-06 4.744801984319e-01
+ 7.774000000000e-06 4.745411776471e-01
+ 7.775000000000e-06 4.746021568623e-01
+ 7.776000000000e-06 4.746631360775e-01
+ 7.777000000000e-06 4.747241152927e-01
+ 7.778000000000e-06 4.747850945079e-01
+ 7.779000000000e-06 4.748460737232e-01
+ 7.780000000000e-06 4.749070529384e-01
+ 7.781000000000e-06 4.749680321536e-01
+ 7.782000000000e-06 4.750290113688e-01
+ 7.783000000000e-06 4.750899905840e-01
+ 7.784000000000e-06 4.751509697992e-01
+ 7.785000000000e-06 4.752119490145e-01
+ 7.786000000000e-06 4.752729282297e-01
+ 7.787000000000e-06 4.753339074449e-01
+ 7.788000000000e-06 4.753948866601e-01
+ 7.789000000000e-06 4.754558658753e-01
+ 7.790000000000e-06 4.755168450905e-01
+ 7.791000000000e-06 4.755778243058e-01
+ 7.792000000000e-06 4.756388035210e-01
+ 7.793000000000e-06 4.756997827362e-01
+ 7.794000000000e-06 4.757607619514e-01
+ 7.795000000000e-06 4.758217411666e-01
+ 7.796000000000e-06 4.758827203818e-01
+ 7.797000000000e-06 4.759436995971e-01
+ 7.798000000000e-06 4.760046788123e-01
+ 7.799000000000e-06 4.760656580275e-01
+ 7.800000000000e-06 4.761266372427e-01
+ 7.801000000000e-06 4.761876164579e-01
+ 7.802000000000e-06 4.762485956731e-01
+ 7.803000000000e-06 4.763095748884e-01
+ 7.804000000000e-06 4.763705541036e-01
+ 7.805000000000e-06 4.764315333188e-01
+ 7.806000000000e-06 4.764925125340e-01
+ 7.807000000000e-06 4.765534917492e-01
+ 7.808000000000e-06 4.766144709644e-01
+ 7.809000000000e-06 4.766754501797e-01
+ 7.810000000000e-06 4.767364293949e-01
+ 7.811000000000e-06 4.767974086101e-01
+ 7.812000000000e-06 4.768583878253e-01
+ 7.813000000000e-06 4.769193670405e-01
+ 7.814000000000e-06 4.769803462557e-01
+ 7.815000000000e-06 4.770413254710e-01
+ 7.816000000000e-06 4.771023046862e-01
+ 7.817000000000e-06 4.771632839014e-01
+ 7.818000000000e-06 4.772242631166e-01
+ 7.819000000000e-06 4.772852423318e-01
+ 7.820000000000e-06 4.773462215470e-01
+ 7.821000000000e-06 4.774072007623e-01
+ 7.822000000000e-06 4.774681799775e-01
+ 7.823000000000e-06 4.775291591927e-01
+ 7.824000000000e-06 4.775901384079e-01
+ 7.825000000000e-06 4.776511176231e-01
+ 7.826000000000e-06 4.777120968383e-01
+ 7.827000000000e-06 4.777730760536e-01
+ 7.828000000000e-06 4.778340552688e-01
+ 7.829000000000e-06 4.778950344840e-01
+ 7.830000000000e-06 4.779560136992e-01
+ 7.831000000000e-06 4.780169929144e-01
+ 7.832000000000e-06 4.780779721296e-01
+ 7.833000000000e-06 4.781389513449e-01
+ 7.834000000000e-06 4.781999305601e-01
+ 7.835000000000e-06 4.782609097753e-01
+ 7.836000000000e-06 4.783218889905e-01
+ 7.837000000000e-06 4.783828682057e-01
+ 7.838000000000e-06 4.784438474209e-01
+ 7.839000000000e-06 4.785048266362e-01
+ 7.840000000000e-06 4.785658058514e-01
+ 7.841000000000e-06 4.786267850666e-01
+ 7.842000000000e-06 4.786877642818e-01
+ 7.843000000000e-06 4.787487434970e-01
+ 7.844000000000e-06 4.788097227122e-01
+ 7.845000000000e-06 4.788707019275e-01
+ 7.846000000000e-06 4.789316811427e-01
+ 7.847000000000e-06 4.789926603579e-01
+ 7.848000000000e-06 4.790536395731e-01
+ 7.849000000000e-06 4.791146187883e-01
+ 7.850000000000e-06 4.791755980035e-01
+ 7.851000000000e-06 4.792365772187e-01
+ 7.852000000000e-06 4.792975564340e-01
+ 7.853000000000e-06 4.793585356492e-01
+ 7.854000000000e-06 4.794195148644e-01
+ 7.855000000000e-06 4.794804940796e-01
+ 7.856000000000e-06 4.795414732948e-01
+ 7.857000000000e-06 4.796024525100e-01
+ 7.858000000000e-06 4.796634317253e-01
+ 7.859000000000e-06 4.797244109405e-01
+ 7.860000000000e-06 4.797853901557e-01
+ 7.861000000000e-06 4.798463693709e-01
+ 7.862000000000e-06 4.799073485861e-01
+ 7.863000000000e-06 4.799683278013e-01
+ 7.864000000000e-06 4.800293070166e-01
+ 7.865000000000e-06 4.800902862318e-01
+ 7.866000000000e-06 4.801512654470e-01
+ 7.867000000000e-06 4.802122446622e-01
+ 7.868000000000e-06 4.802732238774e-01
+ 7.869000000000e-06 4.803342030926e-01
+ 7.870000000000e-06 4.803951823079e-01
+ 7.871000000000e-06 4.804561615231e-01
+ 7.872000000000e-06 4.805171407383e-01
+ 7.873000000000e-06 4.805781199535e-01
+ 7.874000000000e-06 4.806390991687e-01
+ 7.875000000000e-06 4.807000783839e-01
+ 7.876000000000e-06 4.807610575992e-01
+ 7.877000000000e-06 4.808220368144e-01
+ 7.878000000000e-06 4.808830160296e-01
+ 7.879000000000e-06 4.809439952448e-01
+ 7.880000000000e-06 4.810049744600e-01
+ 7.881000000000e-06 4.810659536752e-01
+ 7.882000000000e-06 4.811269328905e-01
+ 7.883000000000e-06 4.811879121057e-01
+ 7.884000000000e-06 4.812488913209e-01
+ 7.885000000000e-06 4.813098705361e-01
+ 7.886000000000e-06 4.813708497513e-01
+ 7.887000000000e-06 4.814318289665e-01
+ 7.888000000000e-06 4.814928081818e-01
+ 7.889000000000e-06 4.815537873970e-01
+ 7.890000000000e-06 4.816147666122e-01
+ 7.891000000000e-06 4.816757458274e-01
+ 7.892000000000e-06 4.817367250426e-01
+ 7.893000000000e-06 4.817977042578e-01
+ 7.894000000000e-06 4.818586834731e-01
+ 7.895000000000e-06 4.819196626883e-01
+ 7.896000000000e-06 4.819806419035e-01
+ 7.897000000000e-06 4.820416211187e-01
+ 7.898000000000e-06 4.821026003339e-01
+ 7.899000000000e-06 4.821635795491e-01
+ 7.900000000000e-06 4.822245587644e-01
+ 7.901000000000e-06 4.822855379796e-01
+ 7.902000000000e-06 4.823465171948e-01
+ 7.903000000000e-06 4.824074964100e-01
+ 7.904000000000e-06 4.824684756252e-01
+ 7.905000000000e-06 4.825294548404e-01
+ 7.906000000000e-06 4.825904340557e-01
+ 7.907000000000e-06 4.826514132709e-01
+ 7.908000000000e-06 4.827123924861e-01
+ 7.909000000000e-06 4.827733717013e-01
+ 7.910000000000e-06 4.828343509165e-01
+ 7.911000000000e-06 4.828953301317e-01
+ 7.912000000000e-06 4.829563093470e-01
+ 7.913000000000e-06 4.830172885622e-01
+ 7.914000000000e-06 4.830782677774e-01
+ 7.915000000000e-06 4.831392469926e-01
+ 7.916000000000e-06 4.832002262078e-01
+ 7.917000000000e-06 4.832612054230e-01
+ 7.918000000000e-06 4.833221846383e-01
+ 7.919000000000e-06 4.833831638535e-01
+ 7.920000000000e-06 4.834441430687e-01
+ 7.921000000000e-06 4.835051222839e-01
+ 7.922000000000e-06 4.835661014991e-01
+ 7.923000000000e-06 4.836270807143e-01
+ 7.924000000000e-06 4.836880599296e-01
+ 7.925000000000e-06 4.837490391448e-01
+ 7.926000000000e-06 4.838100183600e-01
+ 7.927000000000e-06 4.838709975752e-01
+ 7.928000000000e-06 4.839319767904e-01
+ 7.929000000000e-06 4.839929560056e-01
+ 7.930000000000e-06 4.840539352209e-01
+ 7.931000000000e-06 4.841149144361e-01
+ 7.932000000000e-06 4.841758936513e-01
+ 7.933000000000e-06 4.842368728665e-01
+ 7.934000000000e-06 4.842978520817e-01
+ 7.935000000000e-06 4.843588312969e-01
+ 7.936000000000e-06 4.844198105122e-01
+ 7.937000000000e-06 4.844807897274e-01
+ 7.938000000000e-06 4.845417689426e-01
+ 7.939000000000e-06 4.846027481578e-01
+ 7.940000000000e-06 4.846637273730e-01
+ 7.941000000000e-06 4.847247065882e-01
+ 7.942000000000e-06 4.847856858035e-01
+ 7.943000000000e-06 4.848466650187e-01
+ 7.944000000000e-06 4.849076442339e-01
+ 7.945000000000e-06 4.849686234491e-01
+ 7.946000000000e-06 4.850296026643e-01
+ 7.947000000000e-06 4.850905818795e-01
+ 7.948000000000e-06 4.851515610948e-01
+ 7.949000000000e-06 4.852125403100e-01
+ 7.950000000000e-06 4.852735195252e-01
+ 7.951000000000e-06 4.853344987404e-01
+ 7.952000000000e-06 4.853954779556e-01
+ 7.953000000000e-06 4.854564571708e-01
+ 7.954000000000e-06 4.855174363861e-01
+ 7.955000000000e-06 4.855784156013e-01
+ 7.956000000000e-06 4.856393948165e-01
+ 7.957000000000e-06 4.857003740317e-01
+ 7.958000000000e-06 4.857613532469e-01
+ 7.959000000000e-06 4.858223324621e-01
+ 7.960000000000e-06 4.858833116774e-01
+ 7.961000000000e-06 4.859442908926e-01
+ 7.962000000000e-06 4.860052701078e-01
+ 7.963000000000e-06 4.860662493230e-01
+ 7.964000000000e-06 4.861272285382e-01
+ 7.965000000000e-06 4.861882077534e-01
+ 7.966000000000e-06 4.862491869687e-01
+ 7.967000000000e-06 4.863101661839e-01
+ 7.968000000000e-06 4.863711453991e-01
+ 7.969000000000e-06 4.864321246143e-01
+ 7.970000000000e-06 4.864931038295e-01
+ 7.971000000000e-06 4.865540830447e-01
+ 7.972000000000e-06 4.866150622600e-01
+ 7.973000000000e-06 4.866760414752e-01
+ 7.974000000000e-06 4.867370206904e-01
+ 7.975000000000e-06 4.867979999056e-01
+ 7.976000000000e-06 4.868589791208e-01
+ 7.977000000000e-06 4.869199583360e-01
+ 7.978000000000e-06 4.869809375513e-01
+ 7.979000000000e-06 4.870419167665e-01
+ 7.980000000000e-06 4.871028959817e-01
+ 7.981000000000e-06 4.871638751969e-01
+ 7.982000000000e-06 4.872248544121e-01
+ 7.983000000000e-06 4.872858336273e-01
+ 7.984000000000e-06 4.873468128426e-01
+ 7.985000000000e-06 4.874077920578e-01
+ 7.986000000000e-06 4.874687712730e-01
+ 7.987000000000e-06 4.875297504882e-01
+ 7.988000000000e-06 4.875907297034e-01
+ 7.989000000000e-06 4.876517089186e-01
+ 7.990000000000e-06 4.877126881339e-01
+ 7.991000000000e-06 4.877736673491e-01
+ 7.992000000000e-06 4.878346465643e-01
+ 7.993000000000e-06 4.878956257795e-01
+ 7.994000000000e-06 4.879566049947e-01
+ 7.995000000000e-06 4.880175842099e-01
+ 7.996000000000e-06 4.880785634252e-01
+ 7.997000000000e-06 4.881395426404e-01
+ 7.998000000000e-06 4.882005218556e-01
+ 7.999000000000e-06 4.882615010708e-01
+ 8.000000000000e-06 4.883224802860e-01
+ 8.001000000000e-06 4.883834595012e-01
+ 8.002000000000e-06 4.884444387165e-01
+ 8.003000000000e-06 4.885054179317e-01
+ 8.004000000000e-06 4.885663971469e-01
+ 8.005000000000e-06 4.886273763621e-01
+ 8.006000000000e-06 4.886883555773e-01
+ 8.007000000000e-06 4.887493347925e-01
+ 8.008000000000e-06 4.888103140078e-01
+ 8.009000000000e-06 4.888712932230e-01
+ 8.010000000000e-06 4.889322724382e-01
+ 8.011000000000e-06 4.889932516534e-01
+ 8.012000000000e-06 4.890542308686e-01
+ 8.013000000000e-06 4.891152100838e-01
+ 8.014000000000e-06 4.891761892991e-01
+ 8.015000000000e-06 4.892371685143e-01
+ 8.016000000000e-06 4.892981477295e-01
+ 8.017000000000e-06 4.893591269447e-01
+ 8.018000000000e-06 4.894201061599e-01
+ 8.019000000000e-06 4.894810853751e-01
+ 8.020000000000e-06 4.895420645904e-01
+ 8.021000000000e-06 4.896030438056e-01
+ 8.022000000000e-06 4.896640230208e-01
+ 8.023000000000e-06 4.897250022360e-01
+ 8.024000000000e-06 4.897859814512e-01
+ 8.025000000000e-06 4.898469606664e-01
+ 8.026000000000e-06 4.899079398817e-01
+ 8.027000000000e-06 4.899689190969e-01
+ 8.028000000000e-06 4.900298983121e-01
+ 8.029000000000e-06 4.900908775273e-01
+ 8.030000000000e-06 4.901518567425e-01
+ 8.031000000000e-06 4.902128359577e-01
+ 8.032000000000e-06 4.902738151730e-01
+ 8.033000000000e-06 4.903347943882e-01
+ 8.034000000000e-06 4.903957736034e-01
+ 8.035000000000e-06 4.904567528186e-01
+ 8.036000000000e-06 4.905177320338e-01
+ 8.037000000000e-06 4.905787112490e-01
+ 8.038000000000e-06 4.906396904643e-01
+ 8.039000000000e-06 4.907006696795e-01
+ 8.040000000000e-06 4.907616488947e-01
+ 8.041000000000e-06 4.908226281099e-01
+ 8.042000000000e-06 4.908836073251e-01
+ 8.043000000000e-06 4.909445865403e-01
+ 8.044000000000e-06 4.910055657556e-01
+ 8.045000000000e-06 4.910665449708e-01
+ 8.046000000000e-06 4.911275241860e-01
+ 8.047000000000e-06 4.911885034012e-01
+ 8.048000000000e-06 4.912494826164e-01
+ 8.049000000000e-06 4.913104618316e-01
+ 8.050000000000e-06 4.913714410469e-01
+ 8.051000000000e-06 4.914324202621e-01
+ 8.052000000000e-06 4.914933994773e-01
+ 8.053000000000e-06 4.915543786925e-01
+ 8.054000000000e-06 4.916153579077e-01
+ 8.055000000000e-06 4.916763371229e-01
+ 8.056000000000e-06 4.917373163382e-01
+ 8.057000000000e-06 4.917982955534e-01
+ 8.058000000000e-06 4.918592747686e-01
+ 8.059000000000e-06 4.919202539838e-01
+ 8.060000000000e-06 4.919812331990e-01
+ 8.061000000000e-06 4.920422124142e-01
+ 8.062000000000e-06 4.921031916295e-01
+ 8.063000000000e-06 4.921641708447e-01
+ 8.064000000000e-06 4.922251500599e-01
+ 8.065000000000e-06 4.922861292751e-01
+ 8.066000000000e-06 4.923471084903e-01
+ 8.067000000000e-06 4.924080877055e-01
+ 8.068000000000e-06 4.924690669208e-01
+ 8.069000000000e-06 4.925300461360e-01
+ 8.070000000000e-06 4.925910253512e-01
+ 8.071000000000e-06 4.926520045664e-01
+ 8.072000000000e-06 4.927129837816e-01
+ 8.073000000000e-06 4.927739629968e-01
+ 8.074000000000e-06 4.928349422121e-01
+ 8.075000000000e-06 4.928959214273e-01
+ 8.076000000000e-06 4.929569006425e-01
+ 8.077000000000e-06 4.930178798577e-01
+ 8.078000000000e-06 4.930788590729e-01
+ 8.079000000000e-06 4.931398382881e-01
+ 8.080000000000e-06 4.932008175033e-01
+ 8.081000000000e-06 4.932617967186e-01
+ 8.082000000000e-06 4.933227759338e-01
+ 8.083000000000e-06 4.933837551490e-01
+ 8.084000000000e-06 4.934447343642e-01
+ 8.085000000000e-06 4.935057135794e-01
+ 8.086000000000e-06 4.935666927946e-01
+ 8.087000000000e-06 4.936276720099e-01
+ 8.088000000000e-06 4.936886512251e-01
+ 8.089000000000e-06 4.937496304403e-01
+ 8.090000000000e-06 4.938106096555e-01
+ 8.091000000000e-06 4.938715888707e-01
+ 8.092000000000e-06 4.939325680859e-01
+ 8.093000000000e-06 4.939935473012e-01
+ 8.094000000000e-06 4.940545265164e-01
+ 8.095000000000e-06 4.941155057316e-01
+ 8.096000000000e-06 4.941764849468e-01
+ 8.097000000000e-06 4.942374641620e-01
+ 8.098000000000e-06 4.942984433772e-01
+ 8.099000000000e-06 4.943594225925e-01
+ 8.100000000000e-06 4.944204018077e-01
+ 8.101000000000e-06 4.944813810229e-01
+ 8.102000000000e-06 4.945423602381e-01
+ 8.103000000000e-06 4.946033394533e-01
+ 8.104000000000e-06 4.946643186685e-01
+ 8.105000000000e-06 4.947252978838e-01
+ 8.106000000000e-06 4.947862770990e-01
+ 8.107000000000e-06 4.948472563142e-01
+ 8.108000000000e-06 4.949082355294e-01
+ 8.109000000000e-06 4.949692147446e-01
+ 8.110000000000e-06 4.950301939598e-01
+ 8.111000000000e-06 4.950911731751e-01
+ 8.112000000000e-06 4.951521523903e-01
+ 8.113000000000e-06 4.952131316055e-01
+ 8.114000000000e-06 4.952741108207e-01
+ 8.115000000000e-06 4.953350900359e-01
+ 8.116000000000e-06 4.953960692511e-01
+ 8.117000000000e-06 4.954570484664e-01
+ 8.118000000000e-06 4.955180276816e-01
+ 8.119000000000e-06 4.955790068968e-01
+ 8.120000000000e-06 4.956399861120e-01
+ 8.121000000000e-06 4.957009653272e-01
+ 8.122000000000e-06 4.957619445424e-01
+ 8.123000000000e-06 4.958229237577e-01
+ 8.124000000000e-06 4.958839029729e-01
+ 8.125000000000e-06 4.959448821881e-01
+ 8.126000000000e-06 4.960058614033e-01
+ 8.127000000000e-06 4.960668406185e-01
+ 8.128000000000e-06 4.961278198337e-01
+ 8.129000000000e-06 4.961887990490e-01
+ 8.130000000000e-06 4.962497782642e-01
+ 8.131000000000e-06 4.963107574794e-01
+ 8.132000000000e-06 4.963717366946e-01
+ 8.133000000000e-06 4.964327159098e-01
+ 8.134000000000e-06 4.964936951250e-01
+ 8.135000000000e-06 4.965546743403e-01
+ 8.136000000000e-06 4.966156535555e-01
+ 8.137000000000e-06 4.966766327707e-01
+ 8.138000000000e-06 4.967376119859e-01
+ 8.139000000000e-06 4.967985912011e-01
+ 8.140000000000e-06 4.968595704163e-01
+ 8.141000000000e-06 4.969205496316e-01
+ 8.142000000000e-06 4.969815288468e-01
+ 8.143000000000e-06 4.970425080620e-01
+ 8.144000000000e-06 4.971034872772e-01
+ 8.145000000000e-06 4.971644664924e-01
+ 8.146000000000e-06 4.972254457076e-01
+ 8.147000000000e-06 4.972864249229e-01
+ 8.148000000000e-06 4.973474041381e-01
+ 8.149000000000e-06 4.974083833533e-01
+ 8.150000000000e-06 4.974693625685e-01
+ 8.151000000000e-06 4.975303417837e-01
+ 8.152000000000e-06 4.975913209989e-01
+ 8.153000000000e-06 4.976523002142e-01
+ 8.154000000000e-06 4.977132794294e-01
+ 8.155000000000e-06 4.977742586446e-01
+ 8.156000000000e-06 4.978352378598e-01
+ 8.157000000000e-06 4.978962170750e-01
+ 8.158000000000e-06 4.979571962902e-01
+ 8.159000000000e-06 4.980181755055e-01
+ 8.160000000000e-06 4.980791547207e-01
+ 8.161000000000e-06 4.981401339359e-01
+ 8.162000000000e-06 4.982011131511e-01
+ 8.163000000000e-06 4.982620923663e-01
+ 8.164000000000e-06 4.983230715815e-01
+ 8.165000000000e-06 4.983840507968e-01
+ 8.166000000000e-06 4.984450300120e-01
+ 8.167000000000e-06 4.985060092272e-01
+ 8.168000000000e-06 4.985669884424e-01
+ 8.169000000000e-06 4.986279676576e-01
+ 8.170000000000e-06 4.986889468728e-01
+ 8.171000000000e-06 4.987499260881e-01
+ 8.172000000000e-06 4.988109053033e-01
+ 8.173000000000e-06 4.988718845185e-01
+ 8.174000000000e-06 4.989328637337e-01
+ 8.175000000000e-06 4.989938429489e-01
+ 8.176000000000e-06 4.990548221641e-01
+ 8.177000000000e-06 4.991158013794e-01
+ 8.178000000000e-06 4.991767805946e-01
+ 8.179000000000e-06 4.992377598098e-01
+ 8.180000000000e-06 4.992987390250e-01
+ 8.181000000000e-06 4.993597182402e-01
+ 8.182000000000e-06 4.994206974554e-01
+ 8.183000000000e-06 4.994816766707e-01
+ 8.184000000000e-06 4.995426558859e-01
+ 8.185000000000e-06 4.996036351011e-01
+ 8.186000000000e-06 4.996646143163e-01
+ 8.187000000000e-06 4.997255935315e-01
+ 8.188000000000e-06 4.997865727467e-01
+ 8.189000000000e-06 4.998475519620e-01
+ 8.190000000000e-06 4.999085311772e-01
+ 8.191000000000e-06 4.999695103924e-01
+ 8.192000000000e-06 5.000304896076e-01
+ 8.193000000000e-06 5.000914688228e-01
+ 8.194000000000e-06 5.001524480380e-01
+ 8.195000000000e-06 5.002134272533e-01
+ 8.196000000000e-06 5.002744064685e-01
+ 8.197000000000e-06 5.003353856837e-01
+ 8.198000000000e-06 5.003963648989e-01
+ 8.199000000000e-06 5.004573441141e-01
+ 8.200000000000e-06 5.005183233293e-01
+ 8.201000000000e-06 5.005793025446e-01
+ 8.202000000000e-06 5.006402817598e-01
+ 8.203000000000e-06 5.007012609750e-01
+ 8.204000000000e-06 5.007622401902e-01
+ 8.205000000000e-06 5.008232194054e-01
+ 8.206000000000e-06 5.008841986206e-01
+ 8.207000000000e-06 5.009451778359e-01
+ 8.208000000000e-06 5.010061570511e-01
+ 8.209000000000e-06 5.010671362663e-01
+ 8.210000000000e-06 5.011281154815e-01
+ 8.211000000000e-06 5.011890946967e-01
+ 8.212000000000e-06 5.012500739119e-01
+ 8.213000000000e-06 5.013110531272e-01
+ 8.214000000000e-06 5.013720323424e-01
+ 8.215000000000e-06 5.014330115576e-01
+ 8.216000000000e-06 5.014939907728e-01
+ 8.217000000000e-06 5.015549699880e-01
+ 8.218000000000e-06 5.016159492032e-01
+ 8.219000000000e-06 5.016769284185e-01
+ 8.220000000000e-06 5.017379076337e-01
+ 8.221000000000e-06 5.017988868489e-01
+ 8.222000000000e-06 5.018598660641e-01
+ 8.223000000000e-06 5.019208452793e-01
+ 8.224000000000e-06 5.019818244945e-01
+ 8.225000000000e-06 5.020428037098e-01
+ 8.226000000000e-06 5.021037829250e-01
+ 8.227000000000e-06 5.021647621402e-01
+ 8.228000000000e-06 5.022257413554e-01
+ 8.229000000000e-06 5.022867205706e-01
+ 8.230000000000e-06 5.023476997858e-01
+ 8.231000000000e-06 5.024086790011e-01
+ 8.232000000000e-06 5.024696582163e-01
+ 8.233000000000e-06 5.025306374315e-01
+ 8.234000000000e-06 5.025916166467e-01
+ 8.235000000000e-06 5.026525958619e-01
+ 8.236000000000e-06 5.027135750771e-01
+ 8.237000000000e-06 5.027745542924e-01
+ 8.238000000000e-06 5.028355335076e-01
+ 8.239000000000e-06 5.028965127228e-01
+ 8.240000000000e-06 5.029574919380e-01
+ 8.241000000000e-06 5.030184711532e-01
+ 8.242000000000e-06 5.030794503684e-01
+ 8.243000000000e-06 5.031404295837e-01
+ 8.244000000000e-06 5.032014087989e-01
+ 8.245000000000e-06 5.032623880141e-01
+ 8.246000000000e-06 5.033233672293e-01
+ 8.247000000000e-06 5.033843464445e-01
+ 8.248000000000e-06 5.034453256597e-01
+ 8.249000000000e-06 5.035063048750e-01
+ 8.250000000000e-06 5.035672840902e-01
+ 8.251000000000e-06 5.036282633054e-01
+ 8.252000000000e-06 5.036892425206e-01
+ 8.253000000000e-06 5.037502217358e-01
+ 8.254000000000e-06 5.038112009510e-01
+ 8.255000000000e-06 5.038721801663e-01
+ 8.256000000000e-06 5.039331593815e-01
+ 8.257000000000e-06 5.039941385967e-01
+ 8.258000000000e-06 5.040551178119e-01
+ 8.259000000000e-06 5.041160970271e-01
+ 8.260000000000e-06 5.041770762423e-01
+ 8.261000000000e-06 5.042380554576e-01
+ 8.262000000000e-06 5.042990346728e-01
+ 8.263000000000e-06 5.043600138880e-01
+ 8.264000000000e-06 5.044209931032e-01
+ 8.265000000000e-06 5.044819723184e-01
+ 8.266000000000e-06 5.045429515336e-01
+ 8.267000000000e-06 5.046039307489e-01
+ 8.268000000000e-06 5.046649099641e-01
+ 8.269000000000e-06 5.047258891793e-01
+ 8.270000000000e-06 5.047868683945e-01
+ 8.271000000000e-06 5.048478476097e-01
+ 8.272000000000e-06 5.049088268249e-01
+ 8.273000000000e-06 5.049698060402e-01
+ 8.274000000000e-06 5.050307852554e-01
+ 8.275000000000e-06 5.050917644706e-01
+ 8.276000000000e-06 5.051527436858e-01
+ 8.277000000000e-06 5.052137229010e-01
+ 8.278000000000e-06 5.052747021162e-01
+ 8.279000000000e-06 5.053356813315e-01
+ 8.280000000000e-06 5.053966605467e-01
+ 8.281000000000e-06 5.054576397619e-01
+ 8.282000000000e-06 5.055186189771e-01
+ 8.283000000000e-06 5.055795981923e-01
+ 8.284000000000e-06 5.056405774075e-01
+ 8.285000000000e-06 5.057015566228e-01
+ 8.286000000000e-06 5.057625358380e-01
+ 8.287000000000e-06 5.058235150532e-01
+ 8.288000000000e-06 5.058844942684e-01
+ 8.289000000000e-06 5.059454734836e-01
+ 8.290000000000e-06 5.060064526988e-01
+ 8.291000000000e-06 5.060674319141e-01
+ 8.292000000000e-06 5.061284111293e-01
+ 8.293000000000e-06 5.061893903445e-01
+ 8.294000000000e-06 5.062503695597e-01
+ 8.295000000000e-06 5.063113487749e-01
+ 8.296000000000e-06 5.063723279901e-01
+ 8.297000000000e-06 5.064333072054e-01
+ 8.298000000000e-06 5.064942864206e-01
+ 8.299000000000e-06 5.065552656358e-01
+ 8.300000000000e-06 5.066162448510e-01
+ 8.301000000000e-06 5.066772240662e-01
+ 8.302000000000e-06 5.067382032814e-01
+ 8.303000000000e-06 5.067991824967e-01
+ 8.304000000000e-06 5.068601617119e-01
+ 8.305000000000e-06 5.069211409271e-01
+ 8.306000000000e-06 5.069821201423e-01
+ 8.307000000000e-06 5.070430993575e-01
+ 8.308000000000e-06 5.071040785727e-01
+ 8.309000000000e-06 5.071650577879e-01
+ 8.310000000000e-06 5.072260370032e-01
+ 8.311000000000e-06 5.072870162184e-01
+ 8.312000000000e-06 5.073479954336e-01
+ 8.313000000000e-06 5.074089746488e-01
+ 8.314000000000e-06 5.074699538640e-01
+ 8.315000000000e-06 5.075309330792e-01
+ 8.316000000000e-06 5.075919122945e-01
+ 8.317000000000e-06 5.076528915097e-01
+ 8.318000000000e-06 5.077138707249e-01
+ 8.319000000000e-06 5.077748499401e-01
+ 8.320000000000e-06 5.078358291553e-01
+ 8.321000000000e-06 5.078968083705e-01
+ 8.322000000000e-06 5.079577875858e-01
+ 8.323000000000e-06 5.080187668010e-01
+ 8.324000000000e-06 5.080797460162e-01
+ 8.325000000000e-06 5.081407252314e-01
+ 8.326000000000e-06 5.082017044466e-01
+ 8.327000000000e-06 5.082626836618e-01
+ 8.328000000000e-06 5.083236628771e-01
+ 8.329000000000e-06 5.083846420923e-01
+ 8.330000000000e-06 5.084456213075e-01
+ 8.331000000000e-06 5.085066005227e-01
+ 8.332000000000e-06 5.085675797379e-01
+ 8.333000000000e-06 5.086285589531e-01
+ 8.334000000000e-06 5.086895381684e-01
+ 8.335000000000e-06 5.087505173836e-01
+ 8.336000000000e-06 5.088114965988e-01
+ 8.337000000000e-06 5.088724758140e-01
+ 8.338000000000e-06 5.089334550292e-01
+ 8.339000000000e-06 5.089944342444e-01
+ 8.340000000000e-06 5.090554134597e-01
+ 8.341000000000e-06 5.091163926749e-01
+ 8.342000000000e-06 5.091773718901e-01
+ 8.343000000000e-06 5.092383511053e-01
+ 8.344000000000e-06 5.092993303205e-01
+ 8.345000000000e-06 5.093603095357e-01
+ 8.346000000000e-06 5.094212887510e-01
+ 8.347000000000e-06 5.094822679662e-01
+ 8.348000000000e-06 5.095432471814e-01
+ 8.349000000000e-06 5.096042263966e-01
+ 8.350000000000e-06 5.096652056118e-01
+ 8.351000000000e-06 5.097261848270e-01
+ 8.352000000000e-06 5.097871640423e-01
+ 8.353000000000e-06 5.098481432575e-01
+ 8.354000000000e-06 5.099091224727e-01
+ 8.355000000000e-06 5.099701016879e-01
+ 8.356000000000e-06 5.100310809031e-01
+ 8.357000000000e-06 5.100920601183e-01
+ 8.358000000000e-06 5.101530393336e-01
+ 8.359000000000e-06 5.102140185488e-01
+ 8.360000000000e-06 5.102749977640e-01
+ 8.361000000000e-06 5.103359769792e-01
+ 8.362000000000e-06 5.103969561944e-01
+ 8.363000000000e-06 5.104579354096e-01
+ 8.364000000000e-06 5.105189146249e-01
+ 8.365000000000e-06 5.105798938401e-01
+ 8.366000000000e-06 5.106408730553e-01
+ 8.367000000000e-06 5.107018522705e-01
+ 8.368000000000e-06 5.107628314857e-01
+ 8.369000000000e-06 5.108238107009e-01
+ 8.370000000000e-06 5.108847899162e-01
+ 8.371000000000e-06 5.109457691314e-01
+ 8.372000000000e-06 5.110067483466e-01
+ 8.373000000000e-06 5.110677275618e-01
+ 8.374000000000e-06 5.111287067770e-01
+ 8.375000000000e-06 5.111896859922e-01
+ 8.376000000000e-06 5.112506652075e-01
+ 8.377000000000e-06 5.113116444227e-01
+ 8.378000000000e-06 5.113726236379e-01
+ 8.379000000000e-06 5.114336028531e-01
+ 8.380000000000e-06 5.114945820683e-01
+ 8.381000000000e-06 5.115555612835e-01
+ 8.382000000000e-06 5.116165404988e-01
+ 8.383000000000e-06 5.116775197140e-01
+ 8.384000000000e-06 5.117384989292e-01
+ 8.385000000000e-06 5.117994781444e-01
+ 8.386000000000e-06 5.118604573596e-01
+ 8.387000000000e-06 5.119214365748e-01
+ 8.388000000000e-06 5.119824157901e-01
+ 8.389000000000e-06 5.120433950053e-01
+ 8.390000000000e-06 5.121043742205e-01
+ 8.391000000000e-06 5.121653534357e-01
+ 8.392000000000e-06 5.122263326509e-01
+ 8.393000000000e-06 5.122873118661e-01
+ 8.394000000000e-06 5.123482910814e-01
+ 8.395000000000e-06 5.124092702966e-01
+ 8.396000000000e-06 5.124702495118e-01
+ 8.397000000000e-06 5.125312287270e-01
+ 8.398000000000e-06 5.125922079422e-01
+ 8.399000000000e-06 5.126531871574e-01
+ 8.400000000000e-06 5.127141663727e-01
+ 8.401000000000e-06 5.127751455879e-01
+ 8.402000000000e-06 5.128361248031e-01
+ 8.403000000000e-06 5.128971040183e-01
+ 8.404000000000e-06 5.129580832335e-01
+ 8.405000000000e-06 5.130190624487e-01
+ 8.406000000000e-06 5.130800416640e-01
+ 8.407000000000e-06 5.131410208792e-01
+ 8.408000000000e-06 5.132020000944e-01
+ 8.409000000000e-06 5.132629793096e-01
+ 8.410000000000e-06 5.133239585248e-01
+ 8.411000000000e-06 5.133849377400e-01
+ 8.412000000000e-06 5.134459169553e-01
+ 8.413000000000e-06 5.135068961705e-01
+ 8.414000000000e-06 5.135678753857e-01
+ 8.415000000000e-06 5.136288546009e-01
+ 8.416000000000e-06 5.136898338161e-01
+ 8.417000000000e-06 5.137508130313e-01
+ 8.418000000000e-06 5.138117922466e-01
+ 8.419000000000e-06 5.138727714618e-01
+ 8.420000000000e-06 5.139337506770e-01
+ 8.421000000000e-06 5.139947298922e-01
+ 8.422000000000e-06 5.140557091074e-01
+ 8.423000000000e-06 5.141166883226e-01
+ 8.424000000000e-06 5.141776675379e-01
+ 8.425000000000e-06 5.142386467531e-01
+ 8.426000000000e-06 5.142996259683e-01
+ 8.427000000000e-06 5.143606051835e-01
+ 8.428000000000e-06 5.144215843987e-01
+ 8.429000000000e-06 5.144825636139e-01
+ 8.430000000000e-06 5.145435428292e-01
+ 8.431000000000e-06 5.146045220444e-01
+ 8.432000000000e-06 5.146655012596e-01
+ 8.433000000000e-06 5.147264804748e-01
+ 8.434000000000e-06 5.147874596900e-01
+ 8.435000000000e-06 5.148484389052e-01
+ 8.436000000000e-06 5.149094181205e-01
+ 8.437000000000e-06 5.149703973357e-01
+ 8.438000000000e-06 5.150313765509e-01
+ 8.439000000000e-06 5.150923557661e-01
+ 8.440000000000e-06 5.151533349813e-01
+ 8.441000000000e-06 5.152143141965e-01
+ 8.442000000000e-06 5.152752934118e-01
+ 8.443000000000e-06 5.153362726270e-01
+ 8.444000000000e-06 5.153972518422e-01
+ 8.445000000000e-06 5.154582310574e-01
+ 8.446000000000e-06 5.155192102726e-01
+ 8.447000000000e-06 5.155801894878e-01
+ 8.448000000000e-06 5.156411687031e-01
+ 8.449000000000e-06 5.157021479183e-01
+ 8.450000000000e-06 5.157631271335e-01
+ 8.451000000000e-06 5.158241063487e-01
+ 8.452000000000e-06 5.158850855639e-01
+ 8.453000000000e-06 5.159460647791e-01
+ 8.454000000000e-06 5.160070439944e-01
+ 8.455000000000e-06 5.160680232096e-01
+ 8.456000000000e-06 5.161290024248e-01
+ 8.457000000000e-06 5.161899816400e-01
+ 8.458000000000e-06 5.162509608552e-01
+ 8.459000000000e-06 5.163119400704e-01
+ 8.460000000000e-06 5.163729192857e-01
+ 8.461000000000e-06 5.164338985009e-01
+ 8.462000000000e-06 5.164948777161e-01
+ 8.463000000000e-06 5.165558569313e-01
+ 8.464000000000e-06 5.166168361465e-01
+ 8.465000000000e-06 5.166778153617e-01
+ 8.466000000000e-06 5.167387945770e-01
+ 8.467000000000e-06 5.167997737922e-01
+ 8.468000000000e-06 5.168607530074e-01
+ 8.469000000000e-06 5.169217322226e-01
+ 8.470000000000e-06 5.169827114378e-01
+ 8.471000000000e-06 5.170436906530e-01
+ 8.472000000000e-06 5.171046698683e-01
+ 8.473000000000e-06 5.171656490835e-01
+ 8.474000000000e-06 5.172266282987e-01
+ 8.475000000000e-06 5.172876075139e-01
+ 8.476000000000e-06 5.173485867291e-01
+ 8.477000000000e-06 5.174095659443e-01
+ 8.478000000000e-06 5.174705451596e-01
+ 8.479000000000e-06 5.175315243748e-01
+ 8.480000000000e-06 5.175925035900e-01
+ 8.481000000000e-06 5.176534828052e-01
+ 8.482000000000e-06 5.177144620204e-01
+ 8.483000000000e-06 5.177754412356e-01
+ 8.484000000000e-06 5.178364204509e-01
+ 8.485000000000e-06 5.178973996661e-01
+ 8.486000000000e-06 5.179583788813e-01
+ 8.487000000000e-06 5.180193580965e-01
+ 8.488000000000e-06 5.180803373117e-01
+ 8.489000000000e-06 5.181413165269e-01
+ 8.490000000000e-06 5.182022957422e-01
+ 8.491000000000e-06 5.182632749574e-01
+ 8.492000000000e-06 5.183242541726e-01
+ 8.493000000000e-06 5.183852333878e-01
+ 8.494000000000e-06 5.184462126030e-01
+ 8.495000000000e-06 5.185071918182e-01
+ 8.496000000000e-06 5.185681710335e-01
+ 8.497000000000e-06 5.186291502487e-01
+ 8.498000000000e-06 5.186901294639e-01
+ 8.499000000000e-06 5.187511086791e-01
+ 8.500000000000e-06 5.188120878943e-01
+ 8.501000000000e-06 5.188730671095e-01
+ 8.502000000000e-06 5.189340463248e-01
+ 8.503000000000e-06 5.189950255400e-01
+ 8.504000000000e-06 5.190560047552e-01
+ 8.505000000000e-06 5.191169839704e-01
+ 8.506000000000e-06 5.191779631856e-01
+ 8.507000000000e-06 5.192389424008e-01
+ 8.508000000000e-06 5.192999216161e-01
+ 8.509000000000e-06 5.193609008313e-01
+ 8.510000000000e-06 5.194218800465e-01
+ 8.511000000000e-06 5.194828592617e-01
+ 8.512000000000e-06 5.195438384769e-01
+ 8.513000000000e-06 5.196048176921e-01
+ 8.514000000000e-06 5.196657969074e-01
+ 8.515000000000e-06 5.197267761226e-01
+ 8.516000000000e-06 5.197877553378e-01
+ 8.517000000000e-06 5.198487345530e-01
+ 8.518000000000e-06 5.199097137682e-01
+ 8.519000000000e-06 5.199706929834e-01
+ 8.520000000000e-06 5.200316721987e-01
+ 8.521000000000e-06 5.200926514139e-01
+ 8.522000000000e-06 5.201536306291e-01
+ 8.523000000000e-06 5.202146098443e-01
+ 8.524000000000e-06 5.202755890595e-01
+ 8.525000000000e-06 5.203365682747e-01
+ 8.526000000000e-06 5.203975474900e-01
+ 8.527000000000e-06 5.204585267052e-01
+ 8.528000000000e-06 5.205195059204e-01
+ 8.529000000000e-06 5.205804851356e-01
+ 8.530000000000e-06 5.206414643508e-01
+ 8.531000000000e-06 5.207024435660e-01
+ 8.532000000000e-06 5.207634227813e-01
+ 8.533000000000e-06 5.208244019965e-01
+ 8.534000000000e-06 5.208853812117e-01
+ 8.535000000000e-06 5.209463604269e-01
+ 8.536000000000e-06 5.210073396421e-01
+ 8.537000000000e-06 5.210683188573e-01
+ 8.538000000000e-06 5.211292980725e-01
+ 8.539000000000e-06 5.211902772878e-01
+ 8.540000000000e-06 5.212512565030e-01
+ 8.541000000000e-06 5.213122357182e-01
+ 8.542000000000e-06 5.213732149334e-01
+ 8.543000000000e-06 5.214341941486e-01
+ 8.544000000000e-06 5.214951733638e-01
+ 8.545000000000e-06 5.215561525791e-01
+ 8.546000000000e-06 5.216171317943e-01
+ 8.547000000000e-06 5.216781110095e-01
+ 8.548000000000e-06 5.217390902247e-01
+ 8.549000000000e-06 5.218000694399e-01
+ 8.550000000000e-06 5.218610486551e-01
+ 8.551000000000e-06 5.219220278704e-01
+ 8.552000000000e-06 5.219830070856e-01
+ 8.553000000000e-06 5.220439863008e-01
+ 8.554000000000e-06 5.221049655160e-01
+ 8.555000000000e-06 5.221659447312e-01
+ 8.556000000000e-06 5.222269239464e-01
+ 8.557000000000e-06 5.222879031617e-01
+ 8.558000000000e-06 5.223488823769e-01
+ 8.559000000000e-06 5.224098615921e-01
+ 8.560000000000e-06 5.224708408073e-01
+ 8.561000000000e-06 5.225318200225e-01
+ 8.562000000000e-06 5.225927992377e-01
+ 8.563000000000e-06 5.226537784530e-01
+ 8.564000000000e-06 5.227147576682e-01
+ 8.565000000000e-06 5.227757368834e-01
+ 8.566000000000e-06 5.228367160986e-01
+ 8.567000000000e-06 5.228976953138e-01
+ 8.568000000000e-06 5.229586745290e-01
+ 8.569000000000e-06 5.230196537443e-01
+ 8.570000000000e-06 5.230806329595e-01
+ 8.571000000000e-06 5.231416121747e-01
+ 8.572000000000e-06 5.232025913899e-01
+ 8.573000000000e-06 5.232635706051e-01
+ 8.574000000000e-06 5.233245498203e-01
+ 8.575000000000e-06 5.233855290356e-01
+ 8.576000000000e-06 5.234465082508e-01
+ 8.577000000000e-06 5.235074874660e-01
+ 8.578000000000e-06 5.235684666812e-01
+ 8.579000000000e-06 5.236294458964e-01
+ 8.580000000000e-06 5.236904251116e-01
+ 8.581000000000e-06 5.237514043269e-01
+ 8.582000000000e-06 5.238123835421e-01
+ 8.583000000000e-06 5.238733627573e-01
+ 8.584000000000e-06 5.239343419725e-01
+ 8.585000000000e-06 5.239953211877e-01
+ 8.586000000000e-06 5.240563004029e-01
+ 8.587000000000e-06 5.241172796182e-01
+ 8.588000000000e-06 5.241782588334e-01
+ 8.589000000000e-06 5.242392380486e-01
+ 8.590000000000e-06 5.243002172638e-01
+ 8.591000000000e-06 5.243611964790e-01
+ 8.592000000000e-06 5.244221756942e-01
+ 8.593000000000e-06 5.244831549095e-01
+ 8.594000000000e-06 5.245441341247e-01
+ 8.595000000000e-06 5.246051133399e-01
+ 8.596000000000e-06 5.246660925551e-01
+ 8.597000000000e-06 5.247270717703e-01
+ 8.598000000000e-06 5.247880509855e-01
+ 8.599000000000e-06 5.248490302008e-01
+ 8.600000000000e-06 5.249100094160e-01
+ 8.601000000000e-06 5.249709886312e-01
+ 8.602000000000e-06 5.250319678464e-01
+ 8.603000000000e-06 5.250929470616e-01
+ 8.604000000000e-06 5.251539262768e-01
+ 8.605000000000e-06 5.252149054921e-01
+ 8.606000000000e-06 5.252758847073e-01
+ 8.607000000000e-06 5.253368639225e-01
+ 8.608000000000e-06 5.253978431377e-01
+ 8.609000000000e-06 5.254588223529e-01
+ 8.610000000000e-06 5.255198015681e-01
+ 8.611000000000e-06 5.255807807834e-01
+ 8.612000000000e-06 5.256417599986e-01
+ 8.613000000000e-06 5.257027392138e-01
+ 8.614000000000e-06 5.257637184290e-01
+ 8.615000000000e-06 5.258246976442e-01
+ 8.616000000000e-06 5.258856768594e-01
+ 8.617000000000e-06 5.259466560747e-01
+ 8.618000000000e-06 5.260076352899e-01
+ 8.619000000000e-06 5.260686145051e-01
+ 8.620000000000e-06 5.261295937203e-01
+ 8.621000000000e-06 5.261905729355e-01
+ 8.622000000000e-06 5.262515521507e-01
+ 8.623000000000e-06 5.263125313660e-01
+ 8.624000000000e-06 5.263735105812e-01
+ 8.625000000000e-06 5.264344897964e-01
+ 8.626000000000e-06 5.264954690116e-01
+ 8.627000000000e-06 5.265564482268e-01
+ 8.628000000000e-06 5.266174274420e-01
+ 8.629000000000e-06 5.266784066573e-01
+ 8.630000000000e-06 5.267393858725e-01
+ 8.631000000000e-06 5.268003650877e-01
+ 8.632000000000e-06 5.268613443029e-01
+ 8.633000000000e-06 5.269223235181e-01
+ 8.634000000000e-06 5.269833027333e-01
+ 8.635000000000e-06 5.270442819486e-01
+ 8.636000000000e-06 5.271052611638e-01
+ 8.637000000000e-06 5.271662403790e-01
+ 8.638000000000e-06 5.272272195942e-01
+ 8.639000000000e-06 5.272881988094e-01
+ 8.640000000000e-06 5.273491780246e-01
+ 8.641000000000e-06 5.274101572399e-01
+ 8.642000000000e-06 5.274711364551e-01
+ 8.643000000000e-06 5.275321156703e-01
+ 8.644000000000e-06 5.275930948855e-01
+ 8.645000000000e-06 5.276540741007e-01
+ 8.646000000000e-06 5.277150533159e-01
+ 8.647000000000e-06 5.277760325312e-01
+ 8.648000000000e-06 5.278370117464e-01
+ 8.649000000000e-06 5.278979909616e-01
+ 8.650000000000e-06 5.279589701768e-01
+ 8.651000000000e-06 5.280199493920e-01
+ 8.652000000000e-06 5.280809286072e-01
+ 8.653000000000e-06 5.281419078225e-01
+ 8.654000000000e-06 5.282028870377e-01
+ 8.655000000000e-06 5.282638662529e-01
+ 8.656000000000e-06 5.283248454681e-01
+ 8.657000000000e-06 5.283858246833e-01
+ 8.658000000000e-06 5.284468038985e-01
+ 8.659000000000e-06 5.285077831138e-01
+ 8.660000000000e-06 5.285687623290e-01
+ 8.661000000000e-06 5.286297415442e-01
+ 8.662000000000e-06 5.286907207594e-01
+ 8.663000000000e-06 5.287516999746e-01
+ 8.664000000000e-06 5.288126791898e-01
+ 8.665000000000e-06 5.288736584051e-01
+ 8.666000000000e-06 5.289346376203e-01
+ 8.667000000000e-06 5.289956168355e-01
+ 8.668000000000e-06 5.290565960507e-01
+ 8.669000000000e-06 5.291175752659e-01
+ 8.670000000000e-06 5.291785544811e-01
+ 8.671000000000e-06 5.292395336964e-01
+ 8.672000000000e-06 5.293005129116e-01
+ 8.673000000000e-06 5.293614921268e-01
+ 8.674000000000e-06 5.294224713420e-01
+ 8.675000000000e-06 5.294834505572e-01
+ 8.676000000000e-06 5.295444297724e-01
+ 8.677000000000e-06 5.296054089877e-01
+ 8.678000000000e-06 5.296663882029e-01
+ 8.679000000000e-06 5.297273674181e-01
+ 8.680000000000e-06 5.297883466333e-01
+ 8.681000000000e-06 5.298493258485e-01
+ 8.682000000000e-06 5.299103050637e-01
+ 8.683000000000e-06 5.299712842790e-01
+ 8.684000000000e-06 5.300322634942e-01
+ 8.685000000000e-06 5.300932427094e-01
+ 8.686000000000e-06 5.301542219246e-01
+ 8.687000000000e-06 5.302152011398e-01
+ 8.688000000000e-06 5.302761803550e-01
+ 8.689000000000e-06 5.303371595703e-01
+ 8.690000000000e-06 5.303981387855e-01
+ 8.691000000000e-06 5.304591180007e-01
+ 8.692000000000e-06 5.305200972159e-01
+ 8.693000000000e-06 5.305810764311e-01
+ 8.694000000000e-06 5.306420556463e-01
+ 8.695000000000e-06 5.307030348616e-01
+ 8.696000000000e-06 5.307640140768e-01
+ 8.697000000000e-06 5.308249932920e-01
+ 8.698000000000e-06 5.308859725072e-01
+ 8.699000000000e-06 5.309469517224e-01
+ 8.700000000000e-06 5.310079309376e-01
+ 8.701000000000e-06 5.310689101529e-01
+ 8.702000000000e-06 5.311298893681e-01
+ 8.703000000000e-06 5.311908685833e-01
+ 8.704000000000e-06 5.312518477985e-01
+ 8.705000000000e-06 5.313128270137e-01
+ 8.706000000000e-06 5.313738062289e-01
+ 8.707000000000e-06 5.314347854442e-01
+ 8.708000000000e-06 5.314957646594e-01
+ 8.709000000000e-06 5.315567438746e-01
+ 8.710000000000e-06 5.316177230898e-01
+ 8.711000000000e-06 5.316787023050e-01
+ 8.712000000000e-06 5.317396815202e-01
+ 8.713000000000e-06 5.318006607355e-01
+ 8.714000000000e-06 5.318616399507e-01
+ 8.715000000000e-06 5.319226191659e-01
+ 8.716000000000e-06 5.319835983811e-01
+ 8.717000000000e-06 5.320445775963e-01
+ 8.718000000000e-06 5.321055568115e-01
+ 8.719000000000e-06 5.321665360268e-01
+ 8.720000000000e-06 5.322275152420e-01
+ 8.721000000000e-06 5.322884944572e-01
+ 8.722000000000e-06 5.323494736724e-01
+ 8.723000000000e-06 5.324104528876e-01
+ 8.724000000000e-06 5.324714321028e-01
+ 8.725000000000e-06 5.325324113181e-01
+ 8.726000000000e-06 5.325933905333e-01
+ 8.727000000000e-06 5.326543697485e-01
+ 8.728000000000e-06 5.327153489637e-01
+ 8.729000000000e-06 5.327763281789e-01
+ 8.730000000000e-06 5.328373073941e-01
+ 8.731000000000e-06 5.328982866094e-01
+ 8.732000000000e-06 5.329592658246e-01
+ 8.733000000000e-06 5.330202450398e-01
+ 8.734000000000e-06 5.330812242550e-01
+ 8.735000000000e-06 5.331422034702e-01
+ 8.736000000000e-06 5.332031826854e-01
+ 8.737000000000e-06 5.332641619007e-01
+ 8.738000000000e-06 5.333251411159e-01
+ 8.739000000000e-06 5.333861203311e-01
+ 8.740000000000e-06 5.334470995463e-01
+ 8.741000000000e-06 5.335080787615e-01
+ 8.742000000000e-06 5.335690579767e-01
+ 8.743000000000e-06 5.336300371920e-01
+ 8.744000000000e-06 5.336910164072e-01
+ 8.745000000000e-06 5.337519956224e-01
+ 8.746000000000e-06 5.338129748376e-01
+ 8.747000000000e-06 5.338739540528e-01
+ 8.748000000000e-06 5.339349332680e-01
+ 8.749000000000e-06 5.339959124833e-01
+ 8.750000000000e-06 5.340568916985e-01
+ 8.751000000000e-06 5.341178709137e-01
+ 8.752000000000e-06 5.341788501289e-01
+ 8.753000000000e-06 5.342398293441e-01
+ 8.754000000000e-06 5.343008085593e-01
+ 8.755000000000e-06 5.343617877746e-01
+ 8.756000000000e-06 5.344227669898e-01
+ 8.757000000000e-06 5.344837462050e-01
+ 8.758000000000e-06 5.345447254202e-01
+ 8.759000000000e-06 5.346057046354e-01
+ 8.760000000000e-06 5.346666838506e-01
+ 8.761000000000e-06 5.347276630658e-01
+ 8.762000000000e-06 5.347886422811e-01
+ 8.763000000000e-06 5.348496214963e-01
+ 8.764000000000e-06 5.349106007115e-01
+ 8.765000000000e-06 5.349715799267e-01
+ 8.766000000000e-06 5.350325591419e-01
+ 8.767000000000e-06 5.350935383571e-01
+ 8.768000000000e-06 5.351545175724e-01
+ 8.769000000000e-06 5.352154967876e-01
+ 8.770000000000e-06 5.352764760028e-01
+ 8.771000000000e-06 5.353374552180e-01
+ 8.772000000000e-06 5.353984344332e-01
+ 8.773000000000e-06 5.354594136484e-01
+ 8.774000000000e-06 5.355203928637e-01
+ 8.775000000000e-06 5.355813720789e-01
+ 8.776000000000e-06 5.356423512941e-01
+ 8.777000000000e-06 5.357033305093e-01
+ 8.778000000000e-06 5.357643097245e-01
+ 8.779000000000e-06 5.358252889397e-01
+ 8.780000000000e-06 5.358862681550e-01
+ 8.781000000000e-06 5.359472473702e-01
+ 8.782000000000e-06 5.360082265854e-01
+ 8.783000000000e-06 5.360692058006e-01
+ 8.784000000000e-06 5.361301850158e-01
+ 8.785000000000e-06 5.361911642310e-01
+ 8.786000000000e-06 5.362521434463e-01
+ 8.787000000000e-06 5.363131226615e-01
+ 8.788000000000e-06 5.363741018767e-01
+ 8.789000000000e-06 5.364350810919e-01
+ 8.790000000000e-06 5.364960603071e-01
+ 8.791000000000e-06 5.365570395223e-01
+ 8.792000000000e-06 5.366180187376e-01
+ 8.793000000000e-06 5.366789979528e-01
+ 8.794000000000e-06 5.367399771680e-01
+ 8.795000000000e-06 5.368009563832e-01
+ 8.796000000000e-06 5.368619355984e-01
+ 8.797000000000e-06 5.369229148136e-01
+ 8.798000000000e-06 5.369838940289e-01
+ 8.799000000000e-06 5.370448732441e-01
+ 8.800000000000e-06 5.371058524593e-01
+ 8.801000000000e-06 5.371668316745e-01
+ 8.802000000000e-06 5.372278108897e-01
+ 8.803000000000e-06 5.372887901049e-01
+ 8.804000000000e-06 5.373497693202e-01
+ 8.805000000000e-06 5.374107485354e-01
+ 8.806000000000e-06 5.374717277506e-01
+ 8.807000000000e-06 5.375327069658e-01
+ 8.808000000000e-06 5.375936861810e-01
+ 8.809000000000e-06 5.376546653962e-01
+ 8.810000000000e-06 5.377156446115e-01
+ 8.811000000000e-06 5.377766238267e-01
+ 8.812000000000e-06 5.378376030419e-01
+ 8.813000000000e-06 5.378985822571e-01
+ 8.814000000000e-06 5.379595614723e-01
+ 8.815000000000e-06 5.380205406875e-01
+ 8.816000000000e-06 5.380815199028e-01
+ 8.817000000000e-06 5.381424991180e-01
+ 8.818000000000e-06 5.382034783332e-01
+ 8.819000000000e-06 5.382644575484e-01
+ 8.820000000000e-06 5.383254367636e-01
+ 8.821000000000e-06 5.383864159788e-01
+ 8.822000000000e-06 5.384473951941e-01
+ 8.823000000000e-06 5.385083744093e-01
+ 8.824000000000e-06 5.385693536245e-01
+ 8.825000000000e-06 5.386303328397e-01
+ 8.826000000000e-06 5.386913120549e-01
+ 8.827000000000e-06 5.387522912701e-01
+ 8.828000000000e-06 5.388132704854e-01
+ 8.829000000000e-06 5.388742497006e-01
+ 8.830000000000e-06 5.389352289158e-01
+ 8.831000000000e-06 5.389962081310e-01
+ 8.832000000000e-06 5.390571873462e-01
+ 8.833000000000e-06 5.391181665614e-01
+ 8.834000000000e-06 5.391791457767e-01
+ 8.835000000000e-06 5.392401249919e-01
+ 8.836000000000e-06 5.393011042071e-01
+ 8.837000000000e-06 5.393620834223e-01
+ 8.838000000000e-06 5.394230626375e-01
+ 8.839000000000e-06 5.394840418527e-01
+ 8.840000000000e-06 5.395450210680e-01
+ 8.841000000000e-06 5.396060002832e-01
+ 8.842000000000e-06 5.396669794984e-01
+ 8.843000000000e-06 5.397279587136e-01
+ 8.844000000000e-06 5.397889379288e-01
+ 8.845000000000e-06 5.398499171440e-01
+ 8.846000000000e-06 5.399108963593e-01
+ 8.847000000000e-06 5.399718755745e-01
+ 8.848000000000e-06 5.400328547897e-01
+ 8.849000000000e-06 5.400938340049e-01
+ 8.850000000000e-06 5.401548132201e-01
+ 8.851000000000e-06 5.402157924353e-01
+ 8.852000000000e-06 5.402767716506e-01
+ 8.853000000000e-06 5.403377508658e-01
+ 8.854000000000e-06 5.403987300810e-01
+ 8.855000000000e-06 5.404597092962e-01
+ 8.856000000000e-06 5.405206885114e-01
+ 8.857000000000e-06 5.405816677266e-01
+ 8.858000000000e-06 5.406426469419e-01
+ 8.859000000000e-06 5.407036261571e-01
+ 8.860000000000e-06 5.407646053723e-01
+ 8.861000000000e-06 5.408255845875e-01
+ 8.862000000000e-06 5.408865638027e-01
+ 8.863000000000e-06 5.409475430179e-01
+ 8.864000000000e-06 5.410085222332e-01
+ 8.865000000000e-06 5.410695014484e-01
+ 8.866000000000e-06 5.411304806636e-01
+ 8.867000000000e-06 5.411914598788e-01
+ 8.868000000000e-06 5.412524390940e-01
+ 8.869000000000e-06 5.413134183092e-01
+ 8.870000000000e-06 5.413743975245e-01
+ 8.871000000000e-06 5.414353767397e-01
+ 8.872000000000e-06 5.414963559549e-01
+ 8.873000000000e-06 5.415573351701e-01
+ 8.874000000000e-06 5.416183143853e-01
+ 8.875000000000e-06 5.416792936005e-01
+ 8.876000000000e-06 5.417402728158e-01
+ 8.877000000000e-06 5.418012520310e-01
+ 8.878000000000e-06 5.418622312462e-01
+ 8.879000000000e-06 5.419232104614e-01
+ 8.880000000000e-06 5.419841896766e-01
+ 8.881000000000e-06 5.420451688918e-01
+ 8.882000000000e-06 5.421061481071e-01
+ 8.883000000000e-06 5.421671273223e-01
+ 8.884000000000e-06 5.422281065375e-01
+ 8.885000000000e-06 5.422890857527e-01
+ 8.886000000000e-06 5.423500649679e-01
+ 8.887000000000e-06 5.424110441831e-01
+ 8.888000000000e-06 5.424720233984e-01
+ 8.889000000000e-06 5.425330026136e-01
+ 8.890000000000e-06 5.425939818288e-01
+ 8.891000000000e-06 5.426549610440e-01
+ 8.892000000000e-06 5.427159402592e-01
+ 8.893000000000e-06 5.427769194744e-01
+ 8.894000000000e-06 5.428378986897e-01
+ 8.895000000000e-06 5.428988779049e-01
+ 8.896000000000e-06 5.429598571201e-01
+ 8.897000000000e-06 5.430208363353e-01
+ 8.898000000000e-06 5.430818155505e-01
+ 8.899000000000e-06 5.431427947657e-01
+ 8.900000000000e-06 5.432037739810e-01
+ 8.901000000000e-06 5.432647531962e-01
+ 8.902000000000e-06 5.433257324114e-01
+ 8.903000000000e-06 5.433867116266e-01
+ 8.904000000000e-06 5.434476908418e-01
+ 8.905000000000e-06 5.435086700570e-01
+ 8.906000000000e-06 5.435696492723e-01
+ 8.907000000000e-06 5.436306284875e-01
+ 8.908000000000e-06 5.436916077027e-01
+ 8.909000000000e-06 5.437525869179e-01
+ 8.910000000000e-06 5.438135661331e-01
+ 8.911000000000e-06 5.438745453483e-01
+ 8.912000000000e-06 5.439355245636e-01
+ 8.913000000000e-06 5.439965037788e-01
+ 8.914000000000e-06 5.440574829940e-01
+ 8.915000000000e-06 5.441184622092e-01
+ 8.916000000000e-06 5.441794414244e-01
+ 8.917000000000e-06 5.442404206396e-01
+ 8.918000000000e-06 5.443013998549e-01
+ 8.919000000000e-06 5.443623790701e-01
+ 8.920000000000e-06 5.444233582853e-01
+ 8.921000000000e-06 5.444843375005e-01
+ 8.922000000000e-06 5.445453167157e-01
+ 8.923000000000e-06 5.446062959309e-01
+ 8.924000000000e-06 5.446672751462e-01
+ 8.925000000000e-06 5.447282543614e-01
+ 8.926000000000e-06 5.447892335766e-01
+ 8.927000000000e-06 5.448502127918e-01
+ 8.928000000000e-06 5.449111920070e-01
+ 8.929000000000e-06 5.449721712222e-01
+ 8.930000000000e-06 5.450331504375e-01
+ 8.931000000000e-06 5.450941296527e-01
+ 8.932000000000e-06 5.451551088679e-01
+ 8.933000000000e-06 5.452160880831e-01
+ 8.934000000000e-06 5.452770672983e-01
+ 8.935000000000e-06 5.453380465135e-01
+ 8.936000000000e-06 5.453990257288e-01
+ 8.937000000000e-06 5.454600049440e-01
+ 8.938000000000e-06 5.455209841592e-01
+ 8.939000000000e-06 5.455819633744e-01
+ 8.940000000000e-06 5.456429425896e-01
+ 8.941000000000e-06 5.457039218048e-01
+ 8.942000000000e-06 5.457649010201e-01
+ 8.943000000000e-06 5.458258802353e-01
+ 8.944000000000e-06 5.458868594505e-01
+ 8.945000000000e-06 5.459478386657e-01
+ 8.946000000000e-06 5.460088178809e-01
+ 8.947000000000e-06 5.460697970961e-01
+ 8.948000000000e-06 5.461307763114e-01
+ 8.949000000000e-06 5.461917555266e-01
+ 8.950000000000e-06 5.462527347418e-01
+ 8.951000000000e-06 5.463137139570e-01
+ 8.952000000000e-06 5.463746931722e-01
+ 8.953000000000e-06 5.464356723874e-01
+ 8.954000000000e-06 5.464966516027e-01
+ 8.955000000000e-06 5.465576308179e-01
+ 8.956000000000e-06 5.466186100331e-01
+ 8.957000000000e-06 5.466795892483e-01
+ 8.958000000000e-06 5.467405684635e-01
+ 8.959000000000e-06 5.468015476787e-01
+ 8.960000000000e-06 5.468625268940e-01
+ 8.961000000000e-06 5.469235061092e-01
+ 8.962000000000e-06 5.469844853244e-01
+ 8.963000000000e-06 5.470454645396e-01
+ 8.964000000000e-06 5.471064437548e-01
+ 8.965000000000e-06 5.471674229700e-01
+ 8.966000000000e-06 5.472284021853e-01
+ 8.967000000000e-06 5.472893814005e-01
+ 8.968000000000e-06 5.473503606157e-01
+ 8.969000000000e-06 5.474113398309e-01
+ 8.970000000000e-06 5.474723190461e-01
+ 8.971000000000e-06 5.475332982613e-01
+ 8.972000000000e-06 5.475942774766e-01
+ 8.973000000000e-06 5.476552566918e-01
+ 8.974000000000e-06 5.477162359070e-01
+ 8.975000000000e-06 5.477772151222e-01
+ 8.976000000000e-06 5.478381943374e-01
+ 8.977000000000e-06 5.478991735526e-01
+ 8.978000000000e-06 5.479601527679e-01
+ 8.979000000000e-06 5.480211319831e-01
+ 8.980000000000e-06 5.480821111983e-01
+ 8.981000000000e-06 5.481430904135e-01
+ 8.982000000000e-06 5.482040696287e-01
+ 8.983000000000e-06 5.482650488439e-01
+ 8.984000000000e-06 5.483260280592e-01
+ 8.985000000000e-06 5.483870072744e-01
+ 8.986000000000e-06 5.484479864896e-01
+ 8.987000000000e-06 5.485089657048e-01
+ 8.988000000000e-06 5.485699449200e-01
+ 8.989000000000e-06 5.486309241352e-01
+ 8.990000000000e-06 5.486919033504e-01
+ 8.991000000000e-06 5.487528825657e-01
+ 8.992000000000e-06 5.488138617809e-01
+ 8.993000000000e-06 5.488748409961e-01
+ 8.994000000000e-06 5.489358202113e-01
+ 8.995000000000e-06 5.489967994265e-01
+ 8.996000000000e-06 5.490577786417e-01
+ 8.997000000000e-06 5.491187578570e-01
+ 8.998000000000e-06 5.491797370722e-01
+ 8.999000000000e-06 5.492407162874e-01
+ 9.000000000000e-06 5.493016955026e-01
+ 9.001000000000e-06 5.493626747178e-01
+ 9.002000000000e-06 5.494236539330e-01
+ 9.003000000000e-06 5.494846331483e-01
+ 9.004000000000e-06 5.495456123635e-01
+ 9.005000000000e-06 5.496065915787e-01
+ 9.006000000000e-06 5.496675707939e-01
+ 9.007000000000e-06 5.497285500091e-01
+ 9.008000000000e-06 5.497895292243e-01
+ 9.009000000000e-06 5.498505084396e-01
+ 9.010000000000e-06 5.499114876548e-01
+ 9.011000000000e-06 5.499724668700e-01
+ 9.012000000000e-06 5.500334460852e-01
+ 9.013000000000e-06 5.500944253004e-01
+ 9.014000000000e-06 5.501554045156e-01
+ 9.015000000000e-06 5.502163837309e-01
+ 9.016000000000e-06 5.502773629461e-01
+ 9.017000000000e-06 5.503383421613e-01
+ 9.018000000000e-06 5.503993213765e-01
+ 9.019000000000e-06 5.504603005917e-01
+ 9.020000000000e-06 5.505212798069e-01
+ 9.021000000000e-06 5.505822590222e-01
+ 9.022000000000e-06 5.506432382374e-01
+ 9.023000000000e-06 5.507042174526e-01
+ 9.024000000000e-06 5.507651966678e-01
+ 9.025000000000e-06 5.508261758830e-01
+ 9.026000000000e-06 5.508871550982e-01
+ 9.027000000000e-06 5.509481343135e-01
+ 9.028000000000e-06 5.510091135287e-01
+ 9.029000000000e-06 5.510700927439e-01
+ 9.030000000000e-06 5.511310719591e-01
+ 9.031000000000e-06 5.511920511743e-01
+ 9.032000000000e-06 5.512530303895e-01
+ 9.033000000000e-06 5.513140096048e-01
+ 9.034000000000e-06 5.513749888200e-01
+ 9.035000000000e-06 5.514359680352e-01
+ 9.036000000000e-06 5.514969472504e-01
+ 9.037000000000e-06 5.515579264656e-01
+ 9.038000000000e-06 5.516189056808e-01
+ 9.039000000000e-06 5.516798848961e-01
+ 9.040000000000e-06 5.517408641113e-01
+ 9.041000000000e-06 5.518018433265e-01
+ 9.042000000000e-06 5.518628225417e-01
+ 9.043000000000e-06 5.519238017569e-01
+ 9.044000000000e-06 5.519847809721e-01
+ 9.045000000000e-06 5.520457601874e-01
+ 9.046000000000e-06 5.521067394026e-01
+ 9.047000000000e-06 5.521677186178e-01
+ 9.048000000000e-06 5.522286978330e-01
+ 9.049000000000e-06 5.522896770482e-01
+ 9.050000000000e-06 5.523506562634e-01
+ 9.051000000000e-06 5.524116354787e-01
+ 9.052000000000e-06 5.524726146939e-01
+ 9.053000000000e-06 5.525335939091e-01
+ 9.054000000000e-06 5.525945731243e-01
+ 9.055000000000e-06 5.526555523395e-01
+ 9.056000000000e-06 5.527165315547e-01
+ 9.057000000000e-06 5.527775107700e-01
+ 9.058000000000e-06 5.528384899852e-01
+ 9.059000000000e-06 5.528994692004e-01
+ 9.060000000000e-06 5.529604484156e-01
+ 9.061000000000e-06 5.530214276308e-01
+ 9.062000000000e-06 5.530824068460e-01
+ 9.063000000000e-06 5.531433860613e-01
+ 9.064000000000e-06 5.532043652765e-01
+ 9.065000000000e-06 5.532653444917e-01
+ 9.066000000000e-06 5.533263237069e-01
+ 9.067000000000e-06 5.533873029221e-01
+ 9.068000000000e-06 5.534482821373e-01
+ 9.069000000000e-06 5.535092613526e-01
+ 9.070000000000e-06 5.535702405678e-01
+ 9.071000000000e-06 5.536312197830e-01
+ 9.072000000000e-06 5.536921989982e-01
+ 9.073000000000e-06 5.537531782134e-01
+ 9.074000000000e-06 5.538141574286e-01
+ 9.075000000000e-06 5.538751366439e-01
+ 9.076000000000e-06 5.539361158591e-01
+ 9.077000000000e-06 5.539970950743e-01
+ 9.078000000000e-06 5.540580742895e-01
+ 9.079000000000e-06 5.541190535047e-01
+ 9.080000000000e-06 5.541800327199e-01
+ 9.081000000000e-06 5.542410119352e-01
+ 9.082000000000e-06 5.543019911504e-01
+ 9.083000000000e-06 5.543629703656e-01
+ 9.084000000000e-06 5.544239495808e-01
+ 9.085000000000e-06 5.544849287960e-01
+ 9.086000000000e-06 5.545459080112e-01
+ 9.087000000000e-06 5.546068872265e-01
+ 9.088000000000e-06 5.546678664417e-01
+ 9.089000000000e-06 5.547288456569e-01
+ 9.090000000000e-06 5.547898248721e-01
+ 9.091000000000e-06 5.548508040873e-01
+ 9.092000000000e-06 5.549117833025e-01
+ 9.093000000000e-06 5.549727625178e-01
+ 9.094000000000e-06 5.550337417330e-01
+ 9.095000000000e-06 5.550947209482e-01
+ 9.096000000000e-06 5.551557001634e-01
+ 9.097000000000e-06 5.552166793786e-01
+ 9.098000000000e-06 5.552776585938e-01
+ 9.099000000000e-06 5.553386378091e-01
+ 9.100000000000e-06 5.553996170243e-01
+ 9.101000000000e-06 5.554605962395e-01
+ 9.102000000000e-06 5.555215754547e-01
+ 9.103000000000e-06 5.555825546699e-01
+ 9.104000000000e-06 5.556435338851e-01
+ 9.105000000000e-06 5.557045131004e-01
+ 9.106000000000e-06 5.557654923156e-01
+ 9.107000000000e-06 5.558264715308e-01
+ 9.108000000000e-06 5.558874507460e-01
+ 9.109000000000e-06 5.559484299612e-01
+ 9.110000000000e-06 5.560094091764e-01
+ 9.111000000000e-06 5.560703883917e-01
+ 9.112000000000e-06 5.561313676069e-01
+ 9.113000000000e-06 5.561923468221e-01
+ 9.114000000000e-06 5.562533260373e-01
+ 9.115000000000e-06 5.563143052525e-01
+ 9.116000000000e-06 5.563752844677e-01
+ 9.117000000000e-06 5.564362636830e-01
+ 9.118000000000e-06 5.564972428982e-01
+ 9.119000000000e-06 5.565582221134e-01
+ 9.120000000000e-06 5.566192013286e-01
+ 9.121000000000e-06 5.566801805438e-01
+ 9.122000000000e-06 5.567411597590e-01
+ 9.123000000000e-06 5.568021389743e-01
+ 9.124000000000e-06 5.568631181895e-01
+ 9.125000000000e-06 5.569240974047e-01
+ 9.126000000000e-06 5.569850766199e-01
+ 9.127000000000e-06 5.570460558351e-01
+ 9.128000000000e-06 5.571070350503e-01
+ 9.129000000000e-06 5.571680142656e-01
+ 9.130000000000e-06 5.572289934808e-01
+ 9.131000000000e-06 5.572899726960e-01
+ 9.132000000000e-06 5.573509519112e-01
+ 9.133000000000e-06 5.574119311264e-01
+ 9.134000000000e-06 5.574729103416e-01
+ 9.135000000000e-06 5.575338895569e-01
+ 9.136000000000e-06 5.575948687721e-01
+ 9.137000000000e-06 5.576558479873e-01
+ 9.138000000000e-06 5.577168272025e-01
+ 9.139000000000e-06 5.577778064177e-01
+ 9.140000000000e-06 5.578387856329e-01
+ 9.141000000000e-06 5.578997648482e-01
+ 9.142000000000e-06 5.579607440634e-01
+ 9.143000000000e-06 5.580217232786e-01
+ 9.144000000000e-06 5.580827024938e-01
+ 9.145000000000e-06 5.581436817090e-01
+ 9.146000000000e-06 5.582046609242e-01
+ 9.147000000000e-06 5.582656401395e-01
+ 9.148000000000e-06 5.583266193547e-01
+ 9.149000000000e-06 5.583875985699e-01
+ 9.150000000000e-06 5.584485777851e-01
+ 9.151000000000e-06 5.585095570003e-01
+ 9.152000000000e-06 5.585705362155e-01
+ 9.153000000000e-06 5.586315154308e-01
+ 9.154000000000e-06 5.586924946460e-01
+ 9.155000000000e-06 5.587534738612e-01
+ 9.156000000000e-06 5.588144530764e-01
+ 9.157000000000e-06 5.588754322916e-01
+ 9.158000000000e-06 5.589364115068e-01
+ 9.159000000000e-06 5.589973907221e-01
+ 9.160000000000e-06 5.590583699373e-01
+ 9.161000000000e-06 5.591193491525e-01
+ 9.162000000000e-06 5.591803283677e-01
+ 9.163000000000e-06 5.592413075829e-01
+ 9.164000000000e-06 5.593022867981e-01
+ 9.165000000000e-06 5.593632660134e-01
+ 9.166000000000e-06 5.594242452286e-01
+ 9.167000000000e-06 5.594852244438e-01
+ 9.168000000000e-06 5.595462036590e-01
+ 9.169000000000e-06 5.596071828742e-01
+ 9.170000000000e-06 5.596681620894e-01
+ 9.171000000000e-06 5.597291413047e-01
+ 9.172000000000e-06 5.597901205199e-01
+ 9.173000000000e-06 5.598510997351e-01
+ 9.174000000000e-06 5.599120789503e-01
+ 9.175000000000e-06 5.599730581655e-01
+ 9.176000000000e-06 5.600340373807e-01
+ 9.177000000000e-06 5.600950165960e-01
+ 9.178000000000e-06 5.601559958112e-01
+ 9.179000000000e-06 5.602169750264e-01
+ 9.180000000000e-06 5.602779542416e-01
+ 9.181000000000e-06 5.603389334568e-01
+ 9.182000000000e-06 5.603999126720e-01
+ 9.183000000000e-06 5.604608918873e-01
+ 9.184000000000e-06 5.605218711025e-01
+ 9.185000000000e-06 5.605828503177e-01
+ 9.186000000000e-06 5.606438295329e-01
+ 9.187000000000e-06 5.607048087481e-01
+ 9.188000000000e-06 5.607657879633e-01
+ 9.189000000000e-06 5.608267671786e-01
+ 9.190000000000e-06 5.608877463938e-01
+ 9.191000000000e-06 5.609487256090e-01
+ 9.192000000000e-06 5.610097048242e-01
+ 9.193000000000e-06 5.610706840394e-01
+ 9.194000000000e-06 5.611316632546e-01
+ 9.195000000000e-06 5.611926424699e-01
+ 9.196000000000e-06 5.612536216851e-01
+ 9.197000000000e-06 5.613146009003e-01
+ 9.198000000000e-06 5.613755801155e-01
+ 9.199000000000e-06 5.614365593307e-01
+ 9.200000000000e-06 5.614975385459e-01
+ 9.201000000000e-06 5.615585177612e-01
+ 9.202000000000e-06 5.616194969764e-01
+ 9.203000000000e-06 5.616804761916e-01
+ 9.204000000000e-06 5.617414554068e-01
+ 9.205000000000e-06 5.618024346220e-01
+ 9.206000000000e-06 5.618634138372e-01
+ 9.207000000000e-06 5.619243930525e-01
+ 9.208000000000e-06 5.619853722677e-01
+ 9.209000000000e-06 5.620463514829e-01
+ 9.210000000000e-06 5.621073306981e-01
+ 9.211000000000e-06 5.621683099133e-01
+ 9.212000000000e-06 5.622292891285e-01
+ 9.213000000000e-06 5.622902683438e-01
+ 9.214000000000e-06 5.623512475590e-01
+ 9.215000000000e-06 5.624122267742e-01
+ 9.216000000000e-06 5.624732059894e-01
+ 9.217000000000e-06 5.625341852046e-01
+ 9.218000000000e-06 5.625951644198e-01
+ 9.219000000000e-06 5.626561436350e-01
+ 9.220000000000e-06 5.627171228503e-01
+ 9.221000000000e-06 5.627781020655e-01
+ 9.222000000000e-06 5.628390812807e-01
+ 9.223000000000e-06 5.629000604959e-01
+ 9.224000000000e-06 5.629610397111e-01
+ 9.225000000000e-06 5.630220189263e-01
+ 9.226000000000e-06 5.630829981416e-01
+ 9.227000000000e-06 5.631439773568e-01
+ 9.228000000000e-06 5.632049565720e-01
+ 9.229000000000e-06 5.632659357872e-01
+ 9.230000000000e-06 5.633269150024e-01
+ 9.231000000000e-06 5.633878942176e-01
+ 9.232000000000e-06 5.634488734329e-01
+ 9.233000000000e-06 5.635098526481e-01
+ 9.234000000000e-06 5.635708318633e-01
+ 9.235000000000e-06 5.636318110785e-01
+ 9.236000000000e-06 5.636927902937e-01
+ 9.237000000000e-06 5.637537695089e-01
+ 9.238000000000e-06 5.638147487242e-01
+ 9.239000000000e-06 5.638757279394e-01
+ 9.240000000000e-06 5.639367071546e-01
+ 9.241000000000e-06 5.639976863698e-01
+ 9.242000000000e-06 5.640586655850e-01
+ 9.243000000000e-06 5.641196448002e-01
+ 9.244000000000e-06 5.641806240155e-01
+ 9.245000000000e-06 5.642416032307e-01
+ 9.246000000000e-06 5.643025824459e-01
+ 9.247000000000e-06 5.643635616611e-01
+ 9.248000000000e-06 5.644245408763e-01
+ 9.249000000000e-06 5.644855200915e-01
+ 9.250000000000e-06 5.645464993068e-01
+ 9.251000000000e-06 5.646074785220e-01
+ 9.252000000000e-06 5.646684577372e-01
+ 9.253000000000e-06 5.647294369524e-01
+ 9.254000000000e-06 5.647904161676e-01
+ 9.255000000000e-06 5.648513953828e-01
+ 9.256000000000e-06 5.649123745981e-01
+ 9.257000000000e-06 5.649733538133e-01
+ 9.258000000000e-06 5.650343330285e-01
+ 9.259000000000e-06 5.650953122437e-01
+ 9.260000000000e-06 5.651562914589e-01
+ 9.261000000000e-06 5.652172706741e-01
+ 9.262000000000e-06 5.652782498894e-01
+ 9.263000000000e-06 5.653392291046e-01
+ 9.264000000000e-06 5.654002083198e-01
+ 9.265000000000e-06 5.654611875350e-01
+ 9.266000000000e-06 5.655221667502e-01
+ 9.267000000000e-06 5.655831459654e-01
+ 9.268000000000e-06 5.656441251807e-01
+ 9.269000000000e-06 5.657051043959e-01
+ 9.270000000000e-06 5.657660836111e-01
+ 9.271000000000e-06 5.658270628263e-01
+ 9.272000000000e-06 5.658880420415e-01
+ 9.273000000000e-06 5.659490212567e-01
+ 9.274000000000e-06 5.660100004720e-01
+ 9.275000000000e-06 5.660709796872e-01
+ 9.276000000000e-06 5.661319589024e-01
+ 9.277000000000e-06 5.661929381176e-01
+ 9.278000000000e-06 5.662539173328e-01
+ 9.279000000000e-06 5.663148965480e-01
+ 9.280000000000e-06 5.663758757633e-01
+ 9.281000000000e-06 5.664368549785e-01
+ 9.282000000000e-06 5.664978341937e-01
+ 9.283000000000e-06 5.665588134089e-01
+ 9.284000000000e-06 5.666197926241e-01
+ 9.285000000000e-06 5.666807718393e-01
+ 9.286000000000e-06 5.667417510546e-01
+ 9.287000000000e-06 5.668027302698e-01
+ 9.288000000000e-06 5.668637094850e-01
+ 9.289000000000e-06 5.669246887002e-01
+ 9.290000000000e-06 5.669856679154e-01
+ 9.291000000000e-06 5.670466471306e-01
+ 9.292000000000e-06 5.671076263459e-01
+ 9.293000000000e-06 5.671686055611e-01
+ 9.294000000000e-06 5.672295847763e-01
+ 9.295000000000e-06 5.672905639915e-01
+ 9.296000000000e-06 5.673515432067e-01
+ 9.297000000000e-06 5.674125224219e-01
+ 9.298000000000e-06 5.674735016372e-01
+ 9.299000000000e-06 5.675344808524e-01
+ 9.300000000000e-06 5.675954600676e-01
+ 9.301000000000e-06 5.676564392828e-01
+ 9.302000000000e-06 5.677174184980e-01
+ 9.303000000000e-06 5.677783977132e-01
+ 9.304000000000e-06 5.678393769285e-01
+ 9.305000000000e-06 5.679003561437e-01
+ 9.306000000000e-06 5.679613353589e-01
+ 9.307000000000e-06 5.680223145741e-01
+ 9.308000000000e-06 5.680832937893e-01
+ 9.309000000000e-06 5.681442730045e-01
+ 9.310000000000e-06 5.682052522198e-01
+ 9.311000000000e-06 5.682662314350e-01
+ 9.312000000000e-06 5.683272106502e-01
+ 9.313000000000e-06 5.683881898654e-01
+ 9.314000000000e-06 5.684491690806e-01
+ 9.315000000000e-06 5.685101482958e-01
+ 9.316000000000e-06 5.685711275111e-01
+ 9.317000000000e-06 5.686321067263e-01
+ 9.318000000000e-06 5.686930859415e-01
+ 9.319000000000e-06 5.687540651567e-01
+ 9.320000000000e-06 5.688150443719e-01
+ 9.321000000000e-06 5.688760235871e-01
+ 9.322000000000e-06 5.689370028024e-01
+ 9.323000000000e-06 5.689979820176e-01
+ 9.324000000000e-06 5.690589612328e-01
+ 9.325000000000e-06 5.691199404480e-01
+ 9.326000000000e-06 5.691809196632e-01
+ 9.327000000000e-06 5.692418988784e-01
+ 9.328000000000e-06 5.693028780937e-01
+ 9.329000000000e-06 5.693638573089e-01
+ 9.330000000000e-06 5.694248365241e-01
+ 9.331000000000e-06 5.694858157393e-01
+ 9.332000000000e-06 5.695467949545e-01
+ 9.333000000000e-06 5.696077741697e-01
+ 9.334000000000e-06 5.696687533850e-01
+ 9.335000000000e-06 5.697297326002e-01
+ 9.336000000000e-06 5.697907118154e-01
+ 9.337000000000e-06 5.698516910306e-01
+ 9.338000000000e-06 5.699126702458e-01
+ 9.339000000000e-06 5.699736494610e-01
+ 9.340000000000e-06 5.700346286763e-01
+ 9.341000000000e-06 5.700956078915e-01
+ 9.342000000000e-06 5.701565871067e-01
+ 9.343000000000e-06 5.702175663219e-01
+ 9.344000000000e-06 5.702785455371e-01
+ 9.345000000000e-06 5.703395247523e-01
+ 9.346000000000e-06 5.704005039676e-01
+ 9.347000000000e-06 5.704614831828e-01
+ 9.348000000000e-06 5.705224623980e-01
+ 9.349000000000e-06 5.705834416132e-01
+ 9.350000000000e-06 5.706444208284e-01
+ 9.351000000000e-06 5.707054000436e-01
+ 9.352000000000e-06 5.707663792589e-01
+ 9.353000000000e-06 5.708273584741e-01
+ 9.354000000000e-06 5.708883376893e-01
+ 9.355000000000e-06 5.709493169045e-01
+ 9.356000000000e-06 5.710102961197e-01
+ 9.357000000000e-06 5.710712753349e-01
+ 9.358000000000e-06 5.711322545502e-01
+ 9.359000000000e-06 5.711932337654e-01
+ 9.360000000000e-06 5.712542129806e-01
+ 9.361000000000e-06 5.713151921958e-01
+ 9.362000000000e-06 5.713761714110e-01
+ 9.363000000000e-06 5.714371506262e-01
+ 9.364000000000e-06 5.714981298415e-01
+ 9.365000000000e-06 5.715591090567e-01
+ 9.366000000000e-06 5.716200882719e-01
+ 9.367000000000e-06 5.716810674871e-01
+ 9.368000000000e-06 5.717420467023e-01
+ 9.369000000000e-06 5.718030259175e-01
+ 9.370000000000e-06 5.718640051328e-01
+ 9.371000000000e-06 5.719249843480e-01
+ 9.372000000000e-06 5.719859635632e-01
+ 9.373000000000e-06 5.720469427784e-01
+ 9.374000000000e-06 5.721079219936e-01
+ 9.375000000000e-06 5.721689012088e-01
+ 9.376000000000e-06 5.722298804241e-01
+ 9.377000000000e-06 5.722908596393e-01
+ 9.378000000000e-06 5.723518388545e-01
+ 9.379000000000e-06 5.724128180697e-01
+ 9.380000000000e-06 5.724737972849e-01
+ 9.381000000000e-06 5.725347765001e-01
+ 9.382000000000e-06 5.725957557154e-01
+ 9.383000000000e-06 5.726567349306e-01
+ 9.384000000000e-06 5.727177141458e-01
+ 9.385000000000e-06 5.727786933610e-01
+ 9.386000000000e-06 5.728396725762e-01
+ 9.387000000000e-06 5.729006517914e-01
+ 9.388000000000e-06 5.729616310067e-01
+ 9.389000000000e-06 5.730226102219e-01
+ 9.390000000000e-06 5.730835894371e-01
+ 9.391000000000e-06 5.731445686523e-01
+ 9.392000000000e-06 5.732055478675e-01
+ 9.393000000000e-06 5.732665270827e-01
+ 9.394000000000e-06 5.733275062980e-01
+ 9.395000000000e-06 5.733884855132e-01
+ 9.396000000000e-06 5.734494647284e-01
+ 9.397000000000e-06 5.735104439436e-01
+ 9.398000000000e-06 5.735714231588e-01
+ 9.399000000000e-06 5.736324023740e-01
+ 9.400000000000e-06 5.736933815893e-01
+ 9.401000000000e-06 5.737543608045e-01
+ 9.402000000000e-06 5.738153400197e-01
+ 9.403000000000e-06 5.738763192349e-01
+ 9.404000000000e-06 5.739372984501e-01
+ 9.405000000000e-06 5.739982776653e-01
+ 9.406000000000e-06 5.740592568806e-01
+ 9.407000000000e-06 5.741202360958e-01
+ 9.408000000000e-06 5.741812153110e-01
+ 9.409000000000e-06 5.742421945262e-01
+ 9.410000000000e-06 5.743031737414e-01
+ 9.411000000000e-06 5.743641529566e-01
+ 9.412000000000e-06 5.744251321719e-01
+ 9.413000000000e-06 5.744861113871e-01
+ 9.414000000000e-06 5.745470906023e-01
+ 9.415000000000e-06 5.746080698175e-01
+ 9.416000000000e-06 5.746690490327e-01
+ 9.417000000000e-06 5.747300282479e-01
+ 9.418000000000e-06 5.747910074632e-01
+ 9.419000000000e-06 5.748519866784e-01
+ 9.420000000000e-06 5.749129658936e-01
+ 9.421000000000e-06 5.749739451088e-01
+ 9.422000000000e-06 5.750349243240e-01
+ 9.423000000000e-06 5.750959035392e-01
+ 9.424000000000e-06 5.751568827545e-01
+ 9.425000000000e-06 5.752178619697e-01
+ 9.426000000000e-06 5.752788411849e-01
+ 9.427000000000e-06 5.753398204001e-01
+ 9.428000000000e-06 5.754007996153e-01
+ 9.429000000000e-06 5.754617788305e-01
+ 9.430000000000e-06 5.755227580458e-01
+ 9.431000000000e-06 5.755837372610e-01
+ 9.432000000000e-06 5.756447164762e-01
+ 9.433000000000e-06 5.757056956914e-01
+ 9.434000000000e-06 5.757666749066e-01
+ 9.435000000000e-06 5.758276541218e-01
+ 9.436000000000e-06 5.758886333371e-01
+ 9.437000000000e-06 5.759496125523e-01
+ 9.438000000000e-06 5.760105917675e-01
+ 9.439000000000e-06 5.760715709827e-01
+ 9.440000000000e-06 5.761325501979e-01
+ 9.441000000000e-06 5.761935294131e-01
+ 9.442000000000e-06 5.762545086284e-01
+ 9.443000000000e-06 5.763154878436e-01
+ 9.444000000000e-06 5.763764670588e-01
+ 9.445000000000e-06 5.764374462740e-01
+ 9.446000000000e-06 5.764984254892e-01
+ 9.447000000000e-06 5.765594047044e-01
+ 9.448000000000e-06 5.766203839196e-01
+ 9.449000000000e-06 5.766813631349e-01
+ 9.450000000000e-06 5.767423423501e-01
+ 9.451000000000e-06 5.768033215653e-01
+ 9.452000000000e-06 5.768643007805e-01
+ 9.453000000000e-06 5.769252799957e-01
+ 9.454000000000e-06 5.769862592109e-01
+ 9.455000000000e-06 5.770472384262e-01
+ 9.456000000000e-06 5.771082176414e-01
+ 9.457000000000e-06 5.771691968566e-01
+ 9.458000000000e-06 5.772301760718e-01
+ 9.459000000000e-06 5.772911552870e-01
+ 9.460000000000e-06 5.773521345022e-01
+ 9.461000000000e-06 5.774131137175e-01
+ 9.462000000000e-06 5.774740929327e-01
+ 9.463000000000e-06 5.775350721479e-01
+ 9.464000000000e-06 5.775960513631e-01
+ 9.465000000000e-06 5.776570305783e-01
+ 9.466000000000e-06 5.777180097935e-01
+ 9.467000000000e-06 5.777789890088e-01
+ 9.468000000000e-06 5.778399682240e-01
+ 9.469000000000e-06 5.779009474392e-01
+ 9.470000000000e-06 5.779619266544e-01
+ 9.471000000000e-06 5.780229058696e-01
+ 9.472000000000e-06 5.780838850848e-01
+ 9.473000000000e-06 5.781448643001e-01
+ 9.474000000000e-06 5.782058435153e-01
+ 9.475000000000e-06 5.782668227305e-01
+ 9.476000000000e-06 5.783278019457e-01
+ 9.477000000000e-06 5.783887811609e-01
+ 9.478000000000e-06 5.784497603761e-01
+ 9.479000000000e-06 5.785107395914e-01
+ 9.480000000000e-06 5.785717188066e-01
+ 9.481000000000e-06 5.786326980218e-01
+ 9.482000000000e-06 5.786936772370e-01
+ 9.483000000000e-06 5.787546564522e-01
+ 9.484000000000e-06 5.788156356674e-01
+ 9.485000000000e-06 5.788766148827e-01
+ 9.486000000000e-06 5.789375940979e-01
+ 9.487000000000e-06 5.789985733131e-01
+ 9.488000000000e-06 5.790595525283e-01
+ 9.489000000000e-06 5.791205317435e-01
+ 9.490000000000e-06 5.791815109587e-01
+ 9.491000000000e-06 5.792424901740e-01
+ 9.492000000000e-06 5.793034693892e-01
+ 9.493000000000e-06 5.793644486044e-01
+ 9.494000000000e-06 5.794254278196e-01
+ 9.495000000000e-06 5.794864070348e-01
+ 9.496000000000e-06 5.795473862500e-01
+ 9.497000000000e-06 5.796083654653e-01
+ 9.498000000000e-06 5.796693446805e-01
+ 9.499000000000e-06 5.797303238957e-01
+ 9.500000000000e-06 5.797913031109e-01
+ 9.501000000000e-06 5.798522823261e-01
+ 9.502000000000e-06 5.799132615413e-01
+ 9.503000000000e-06 5.799742407566e-01
+ 9.504000000000e-06 5.800352199718e-01
+ 9.505000000000e-06 5.800961991870e-01
+ 9.506000000000e-06 5.801571784022e-01
+ 9.507000000000e-06 5.802181576174e-01
+ 9.508000000000e-06 5.802791368326e-01
+ 9.509000000000e-06 5.803401160479e-01
+ 9.510000000000e-06 5.804010952631e-01
+ 9.511000000000e-06 5.804620744783e-01
+ 9.512000000000e-06 5.805230536935e-01
+ 9.513000000000e-06 5.805840329087e-01
+ 9.514000000000e-06 5.806450121239e-01
+ 9.515000000000e-06 5.807059913392e-01
+ 9.516000000000e-06 5.807669705544e-01
+ 9.517000000000e-06 5.808279497696e-01
+ 9.518000000000e-06 5.808889289848e-01
+ 9.519000000000e-06 5.809499082000e-01
+ 9.520000000000e-06 5.810108874152e-01
+ 9.521000000000e-06 5.810718666305e-01
+ 9.522000000000e-06 5.811328458457e-01
+ 9.523000000000e-06 5.811938250609e-01
+ 9.524000000000e-06 5.812548042761e-01
+ 9.525000000000e-06 5.813157834913e-01
+ 9.526000000000e-06 5.813767627065e-01
+ 9.527000000000e-06 5.814377419218e-01
+ 9.528000000000e-06 5.814987211370e-01
+ 9.529000000000e-06 5.815597003522e-01
+ 9.530000000000e-06 5.816206795674e-01
+ 9.531000000000e-06 5.816816587826e-01
+ 9.532000000000e-06 5.817426379978e-01
+ 9.533000000000e-06 5.818036172131e-01
+ 9.534000000000e-06 5.818645964283e-01
+ 9.535000000000e-06 5.819255756435e-01
+ 9.536000000000e-06 5.819865548587e-01
+ 9.537000000000e-06 5.820475340739e-01
+ 9.538000000000e-06 5.821085132891e-01
+ 9.539000000000e-06 5.821694925044e-01
+ 9.540000000000e-06 5.822304717196e-01
+ 9.541000000000e-06 5.822914509348e-01
+ 9.542000000000e-06 5.823524301500e-01
+ 9.543000000000e-06 5.824134093652e-01
+ 9.544000000000e-06 5.824743885804e-01
+ 9.545000000000e-06 5.825353677957e-01
+ 9.546000000000e-06 5.825963470109e-01
+ 9.547000000000e-06 5.826573262261e-01
+ 9.548000000000e-06 5.827183054413e-01
+ 9.549000000000e-06 5.827792846565e-01
+ 9.550000000000e-06 5.828402638717e-01
+ 9.551000000000e-06 5.829012430870e-01
+ 9.552000000000e-06 5.829622223022e-01
+ 9.553000000000e-06 5.830232015174e-01
+ 9.554000000000e-06 5.830841807326e-01
+ 9.555000000000e-06 5.831451599478e-01
+ 9.556000000000e-06 5.832061391630e-01
+ 9.557000000000e-06 5.832671183783e-01
+ 9.558000000000e-06 5.833280975935e-01
+ 9.559000000000e-06 5.833890768087e-01
+ 9.560000000000e-06 5.834500560239e-01
+ 9.561000000000e-06 5.835110352391e-01
+ 9.562000000000e-06 5.835720144543e-01
+ 9.563000000000e-06 5.836329936696e-01
+ 9.564000000000e-06 5.836939728848e-01
+ 9.565000000000e-06 5.837549521000e-01
+ 9.566000000000e-06 5.838159313152e-01
+ 9.567000000000e-06 5.838769105304e-01
+ 9.568000000000e-06 5.839378897456e-01
+ 9.569000000000e-06 5.839988689609e-01
+ 9.570000000000e-06 5.840598481761e-01
+ 9.571000000000e-06 5.841208273913e-01
+ 9.572000000000e-06 5.841818066065e-01
+ 9.573000000000e-06 5.842427858217e-01
+ 9.574000000000e-06 5.843037650369e-01
+ 9.575000000000e-06 5.843647442522e-01
+ 9.576000000000e-06 5.844257234674e-01
+ 9.577000000000e-06 5.844867026826e-01
+ 9.578000000000e-06 5.845476818978e-01
+ 9.579000000000e-06 5.846086611130e-01
+ 9.580000000000e-06 5.846696403282e-01
+ 9.581000000000e-06 5.847306195435e-01
+ 9.582000000000e-06 5.847915987587e-01
+ 9.583000000000e-06 5.848525779739e-01
+ 9.584000000000e-06 5.849135571891e-01
+ 9.585000000000e-06 5.849745364043e-01
+ 9.586000000000e-06 5.850355156195e-01
+ 9.587000000000e-06 5.850964948348e-01
+ 9.588000000000e-06 5.851574740500e-01
+ 9.589000000000e-06 5.852184532652e-01
+ 9.590000000000e-06 5.852794324804e-01
+ 9.591000000000e-06 5.853404116956e-01
+ 9.592000000000e-06 5.854013909108e-01
+ 9.593000000000e-06 5.854623701261e-01
+ 9.594000000000e-06 5.855233493413e-01
+ 9.595000000000e-06 5.855843285565e-01
+ 9.596000000000e-06 5.856453077717e-01
+ 9.597000000000e-06 5.857062869869e-01
+ 9.598000000000e-06 5.857672662021e-01
+ 9.599000000000e-06 5.858282454174e-01
+ 9.600000000000e-06 5.858892246326e-01
+ 9.601000000000e-06 5.859502038478e-01
+ 9.602000000000e-06 5.860111830630e-01
+ 9.603000000000e-06 5.860721622782e-01
+ 9.604000000000e-06 5.861331414934e-01
+ 9.605000000000e-06 5.861941207087e-01
+ 9.606000000000e-06 5.862550999239e-01
+ 9.607000000000e-06 5.863160791391e-01
+ 9.608000000000e-06 5.863770583543e-01
+ 9.609000000000e-06 5.864380375695e-01
+ 9.610000000000e-06 5.864990167847e-01
+ 9.611000000000e-06 5.865599960000e-01
+ 9.612000000000e-06 5.866209752152e-01
+ 9.613000000000e-06 5.866819544304e-01
+ 9.614000000000e-06 5.867429336456e-01
+ 9.615000000000e-06 5.868039128608e-01
+ 9.616000000000e-06 5.868648920760e-01
+ 9.617000000000e-06 5.869258712913e-01
+ 9.618000000000e-06 5.869868505065e-01
+ 9.619000000000e-06 5.870478297217e-01
+ 9.620000000000e-06 5.871088089369e-01
+ 9.621000000000e-06 5.871697881521e-01
+ 9.622000000000e-06 5.872307673673e-01
+ 9.623000000000e-06 5.872917465826e-01
+ 9.624000000000e-06 5.873527257978e-01
+ 9.625000000000e-06 5.874137050130e-01
+ 9.626000000000e-06 5.874746842282e-01
+ 9.627000000000e-06 5.875356634434e-01
+ 9.628000000000e-06 5.875966426586e-01
+ 9.629000000000e-06 5.876576218739e-01
+ 9.630000000000e-06 5.877186010891e-01
+ 9.631000000000e-06 5.877795803043e-01
+ 9.632000000000e-06 5.878405595195e-01
+ 9.633000000000e-06 5.879015387347e-01
+ 9.634000000000e-06 5.879625179499e-01
+ 9.635000000000e-06 5.880234971652e-01
+ 9.636000000000e-06 5.880844763804e-01
+ 9.637000000000e-06 5.881454555956e-01
+ 9.638000000000e-06 5.882064348108e-01
+ 9.639000000000e-06 5.882674140260e-01
+ 9.640000000000e-06 5.883283932412e-01
+ 9.641000000000e-06 5.883893724565e-01
+ 9.642000000000e-06 5.884503516717e-01
+ 9.643000000000e-06 5.885113308869e-01
+ 9.644000000000e-06 5.885723101021e-01
+ 9.645000000000e-06 5.886332893173e-01
+ 9.646000000000e-06 5.886942685325e-01
+ 9.647000000000e-06 5.887552477478e-01
+ 9.648000000000e-06 5.888162269630e-01
+ 9.649000000000e-06 5.888772061782e-01
+ 9.650000000000e-06 5.889381853934e-01
+ 9.651000000000e-06 5.889991646086e-01
+ 9.652000000000e-06 5.890601438238e-01
+ 9.653000000000e-06 5.891211230391e-01
+ 9.654000000000e-06 5.891821022543e-01
+ 9.655000000000e-06 5.892430814695e-01
+ 9.656000000000e-06 5.893040606847e-01
+ 9.657000000000e-06 5.893650398999e-01
+ 9.658000000000e-06 5.894260191151e-01
+ 9.659000000000e-06 5.894869983304e-01
+ 9.660000000000e-06 5.895479775456e-01
+ 9.661000000000e-06 5.896089567608e-01
+ 9.662000000000e-06 5.896699359760e-01
+ 9.663000000000e-06 5.897309151912e-01
+ 9.664000000000e-06 5.897918944064e-01
+ 9.665000000000e-06 5.898528736217e-01
+ 9.666000000000e-06 5.899138528369e-01
+ 9.667000000000e-06 5.899748320521e-01
+ 9.668000000000e-06 5.900358112673e-01
+ 9.669000000000e-06 5.900967904825e-01
+ 9.670000000000e-06 5.901577696977e-01
+ 9.671000000000e-06 5.902187489130e-01
+ 9.672000000000e-06 5.902797281282e-01
+ 9.673000000000e-06 5.903407073434e-01
+ 9.674000000000e-06 5.904016865586e-01
+ 9.675000000000e-06 5.904626657738e-01
+ 9.676000000000e-06 5.905236449890e-01
+ 9.677000000000e-06 5.905846242042e-01
+ 9.678000000000e-06 5.906456034195e-01
+ 9.679000000000e-06 5.907065826347e-01
+ 9.680000000000e-06 5.907675618499e-01
+ 9.681000000000e-06 5.908285410651e-01
+ 9.682000000000e-06 5.908895202803e-01
+ 9.683000000000e-06 5.909504994955e-01
+ 9.684000000000e-06 5.910114787108e-01
+ 9.685000000000e-06 5.910724579260e-01
+ 9.686000000000e-06 5.911334371412e-01
+ 9.687000000000e-06 5.911944163564e-01
+ 9.688000000000e-06 5.912553955716e-01
+ 9.689000000000e-06 5.913163747868e-01
+ 9.690000000000e-06 5.913773540021e-01
+ 9.691000000000e-06 5.914383332173e-01
+ 9.692000000000e-06 5.914993124325e-01
+ 9.693000000000e-06 5.915602916477e-01
+ 9.694000000000e-06 5.916212708629e-01
+ 9.695000000000e-06 5.916822500781e-01
+ 9.696000000000e-06 5.917432292934e-01
+ 9.697000000000e-06 5.918042085086e-01
+ 9.698000000000e-06 5.918651877238e-01
+ 9.699000000000e-06 5.919261669390e-01
+ 9.700000000000e-06 5.919871461542e-01
+ 9.701000000000e-06 5.920481253694e-01
+ 9.702000000000e-06 5.921091045847e-01
+ 9.703000000000e-06 5.921700837999e-01
+ 9.704000000000e-06 5.922310630151e-01
+ 9.705000000000e-06 5.922920422303e-01
+ 9.706000000000e-06 5.923530214455e-01
+ 9.707000000000e-06 5.924140006607e-01
+ 9.708000000000e-06 5.924749798760e-01
+ 9.709000000000e-06 5.925359590912e-01
+ 9.710000000000e-06 5.925969383064e-01
+ 9.711000000000e-06 5.926579175216e-01
+ 9.712000000000e-06 5.927188967368e-01
+ 9.713000000000e-06 5.927798759520e-01
+ 9.714000000000e-06 5.928408551673e-01
+ 9.715000000000e-06 5.929018343825e-01
+ 9.716000000000e-06 5.929628135977e-01
+ 9.717000000000e-06 5.930237928129e-01
+ 9.718000000000e-06 5.930847720281e-01
+ 9.719000000000e-06 5.931457512433e-01
+ 9.720000000000e-06 5.932067304586e-01
+ 9.721000000000e-06 5.932677096738e-01
+ 9.722000000000e-06 5.933286888890e-01
+ 9.723000000000e-06 5.933896681042e-01
+ 9.724000000000e-06 5.934506473194e-01
+ 9.725000000000e-06 5.935116265346e-01
+ 9.726000000000e-06 5.935726057499e-01
+ 9.727000000000e-06 5.936335849651e-01
+ 9.728000000000e-06 5.936945641803e-01
+ 9.729000000000e-06 5.937555433955e-01
+ 9.730000000000e-06 5.938165226107e-01
+ 9.731000000000e-06 5.938775018259e-01
+ 9.732000000000e-06 5.939384810412e-01
+ 9.733000000000e-06 5.939994602564e-01
+ 9.734000000000e-06 5.940604394716e-01
+ 9.735000000000e-06 5.941214186868e-01
+ 9.736000000000e-06 5.941823979020e-01
+ 9.737000000000e-06 5.942433771172e-01
+ 9.738000000000e-06 5.943043563325e-01
+ 9.739000000000e-06 5.943653355477e-01
+ 9.740000000000e-06 5.944263147629e-01
+ 9.741000000000e-06 5.944872939781e-01
+ 9.742000000000e-06 5.945482731933e-01
+ 9.743000000000e-06 5.946092524085e-01
+ 9.744000000000e-06 5.946702316238e-01
+ 9.745000000000e-06 5.947312108390e-01
+ 9.746000000000e-06 5.947921900542e-01
+ 9.747000000000e-06 5.948531692694e-01
+ 9.748000000000e-06 5.949141484846e-01
+ 9.749000000000e-06 5.949751276998e-01
+ 9.750000000000e-06 5.950361069151e-01
+ 9.751000000000e-06 5.950970861303e-01
+ 9.752000000000e-06 5.951580653455e-01
+ 9.753000000000e-06 5.952190445607e-01
+ 9.754000000000e-06 5.952800237759e-01
+ 9.755000000000e-06 5.953410029911e-01
+ 9.756000000000e-06 5.954019822064e-01
+ 9.757000000000e-06 5.954629614216e-01
+ 9.758000000000e-06 5.955239406368e-01
+ 9.759000000000e-06 5.955849198520e-01
+ 9.760000000000e-06 5.956458990672e-01
+ 9.761000000000e-06 5.957068782824e-01
+ 9.762000000000e-06 5.957678574977e-01
+ 9.763000000000e-06 5.958288367129e-01
+ 9.764000000000e-06 5.958898159281e-01
+ 9.765000000000e-06 5.959507951433e-01
+ 9.766000000000e-06 5.960117743585e-01
+ 9.767000000000e-06 5.960727535737e-01
+ 9.768000000000e-06 5.961337327890e-01
+ 9.769000000000e-06 5.961947120042e-01
+ 9.770000000000e-06 5.962556912194e-01
+ 9.771000000000e-06 5.963166704346e-01
+ 9.772000000000e-06 5.963776496498e-01
+ 9.773000000000e-06 5.964386288650e-01
+ 9.774000000000e-06 5.964996080803e-01
+ 9.775000000000e-06 5.965605872955e-01
+ 9.776000000000e-06 5.966215665107e-01
+ 9.777000000000e-06 5.966825457259e-01
+ 9.778000000000e-06 5.967435249411e-01
+ 9.779000000000e-06 5.968045041563e-01
+ 9.780000000000e-06 5.968654833716e-01
+ 9.781000000000e-06 5.969264625868e-01
+ 9.782000000000e-06 5.969874418020e-01
+ 9.783000000000e-06 5.970484210172e-01
+ 9.784000000000e-06 5.971094002324e-01
+ 9.785000000000e-06 5.971703794476e-01
+ 9.786000000000e-06 5.972313586629e-01
+ 9.787000000000e-06 5.972923378781e-01
+ 9.788000000000e-06 5.973533170933e-01
+ 9.789000000000e-06 5.974142963085e-01
+ 9.790000000000e-06 5.974752755237e-01
+ 9.791000000000e-06 5.975362547389e-01
+ 9.792000000000e-06 5.975972339542e-01
+ 9.793000000000e-06 5.976582131694e-01
+ 9.794000000000e-06 5.977191923846e-01
+ 9.795000000000e-06 5.977801715998e-01
+ 9.796000000000e-06 5.978411508150e-01
+ 9.797000000000e-06 5.979021300302e-01
+ 9.798000000000e-06 5.979631092455e-01
+ 9.799000000000e-06 5.980240884607e-01
+ 9.800000000000e-06 5.980850676759e-01
+ 9.801000000000e-06 5.981460468911e-01
+ 9.802000000000e-06 5.982070261063e-01
+ 9.803000000000e-06 5.982680053215e-01
+ 9.804000000000e-06 5.983289845368e-01
+ 9.805000000000e-06 5.983899637520e-01
+ 9.806000000000e-06 5.984509429672e-01
+ 9.807000000000e-06 5.985119221824e-01
+ 9.808000000000e-06 5.985729013976e-01
+ 9.809000000000e-06 5.986338806128e-01
+ 9.810000000000e-06 5.986948598281e-01
+ 9.811000000000e-06 5.987558390433e-01
+ 9.812000000000e-06 5.988168182585e-01
+ 9.813000000000e-06 5.988777974737e-01
+ 9.814000000000e-06 5.989387766889e-01
+ 9.815000000000e-06 5.989997559041e-01
+ 9.816000000000e-06 5.990607351194e-01
+ 9.817000000000e-06 5.991217143346e-01
+ 9.818000000000e-06 5.991826935498e-01
+ 9.819000000000e-06 5.992436727650e-01
+ 9.820000000000e-06 5.993046519802e-01
+ 9.821000000000e-06 5.993656311954e-01
+ 9.822000000000e-06 5.994266104107e-01
+ 9.823000000000e-06 5.994875896259e-01
+ 9.824000000000e-06 5.995485688411e-01
+ 9.825000000000e-06 5.996095480563e-01
+ 9.826000000000e-06 5.996705272715e-01
+ 9.827000000000e-06 5.997315064867e-01
+ 9.828000000000e-06 5.997924857020e-01
+ 9.829000000000e-06 5.998534649172e-01
+ 9.830000000000e-06 5.999144441324e-01
+ 9.831000000000e-06 5.999754233476e-01
+ 9.832000000000e-06 6.000364025628e-01
+ 9.833000000000e-06 6.000973817780e-01
+ 9.834000000000e-06 6.001583609933e-01
+ 9.835000000000e-06 6.002193402085e-01
+ 9.836000000000e-06 6.002803194237e-01
+ 9.837000000000e-06 6.003412986389e-01
+ 9.838000000000e-06 6.004022778541e-01
+ 9.839000000000e-06 6.004632570693e-01
+ 9.840000000000e-06 6.005242362846e-01
+ 9.841000000000e-06 6.005852154998e-01
+ 9.842000000000e-06 6.006461947150e-01
+ 9.843000000000e-06 6.007071739302e-01
+ 9.844000000000e-06 6.007681531454e-01
+ 9.845000000000e-06 6.008291323606e-01
+ 9.846000000000e-06 6.008901115759e-01
+ 9.847000000000e-06 6.009510907911e-01
+ 9.848000000000e-06 6.010120700063e-01
+ 9.849000000000e-06 6.010730492215e-01
+ 9.850000000000e-06 6.011340284367e-01
+ 9.851000000000e-06 6.011950076519e-01
+ 9.852000000000e-06 6.012559868672e-01
+ 9.853000000000e-06 6.013169660824e-01
+ 9.854000000000e-06 6.013779452976e-01
+ 9.855000000000e-06 6.014389245128e-01
+ 9.856000000000e-06 6.014999037280e-01
+ 9.857000000000e-06 6.015608829432e-01
+ 9.858000000000e-06 6.016218621585e-01
+ 9.859000000000e-06 6.016828413737e-01
+ 9.860000000000e-06 6.017438205889e-01
+ 9.861000000000e-06 6.018047998041e-01
+ 9.862000000000e-06 6.018657790193e-01
+ 9.863000000000e-06 6.019267582345e-01
+ 9.864000000000e-06 6.019877374498e-01
+ 9.865000000000e-06 6.020487166650e-01
+ 9.866000000000e-06 6.021096958802e-01
+ 9.867000000000e-06 6.021706750954e-01
+ 9.868000000000e-06 6.022316543106e-01
+ 9.869000000000e-06 6.022926335258e-01
+ 9.870000000000e-06 6.023536127411e-01
+ 9.871000000000e-06 6.024145919563e-01
+ 9.872000000000e-06 6.024755711715e-01
+ 9.873000000000e-06 6.025365503867e-01
+ 9.874000000000e-06 6.025975296019e-01
+ 9.875000000000e-06 6.026585088171e-01
+ 9.876000000000e-06 6.027194880324e-01
+ 9.877000000000e-06 6.027804672476e-01
+ 9.878000000000e-06 6.028414464628e-01
+ 9.879000000000e-06 6.029024256780e-01
+ 9.880000000000e-06 6.029634048932e-01
+ 9.881000000000e-06 6.030243841084e-01
+ 9.882000000000e-06 6.030853633237e-01
+ 9.883000000000e-06 6.031463425389e-01
+ 9.884000000000e-06 6.032073217541e-01
+ 9.885000000000e-06 6.032683009693e-01
+ 9.886000000000e-06 6.033292801845e-01
+ 9.887000000000e-06 6.033902593997e-01
+ 9.888000000000e-06 6.034512386150e-01
+ 9.889000000000e-06 6.035122178302e-01
+ 9.890000000000e-06 6.035731970454e-01
+ 9.891000000000e-06 6.036341762606e-01
+ 9.892000000000e-06 6.036951554758e-01
+ 9.893000000000e-06 6.037561346910e-01
+ 9.894000000000e-06 6.038171139063e-01
+ 9.895000000000e-06 6.038780931215e-01
+ 9.896000000000e-06 6.039390723367e-01
+ 9.897000000000e-06 6.040000515519e-01
+ 9.898000000000e-06 6.040610307671e-01
+ 9.899000000000e-06 6.041220099823e-01
+ 9.900000000000e-06 6.041829891975e-01
+ 9.901000000000e-06 6.042439684128e-01
+ 9.902000000000e-06 6.043049476280e-01
+ 9.903000000000e-06 6.043659268432e-01
+ 9.904000000000e-06 6.044269060584e-01
+ 9.905000000000e-06 6.044878852736e-01
+ 9.906000000000e-06 6.045488644888e-01
+ 9.907000000000e-06 6.046098437041e-01
+ 9.908000000000e-06 6.046708229193e-01
+ 9.909000000000e-06 6.047318021345e-01
+ 9.910000000000e-06 6.047927813497e-01
+ 9.911000000000e-06 6.048537605649e-01
+ 9.912000000000e-06 6.049147397801e-01
+ 9.913000000000e-06 6.049757189954e-01
+ 9.914000000000e-06 6.050366982106e-01
+ 9.915000000000e-06 6.050976774258e-01
+ 9.916000000000e-06 6.051586566410e-01
+ 9.917000000000e-06 6.052196358562e-01
+ 9.918000000000e-06 6.052806150714e-01
+ 9.919000000000e-06 6.053415942867e-01
+ 9.920000000000e-06 6.054025735019e-01
+ 9.921000000000e-06 6.054635527171e-01
+ 9.922000000000e-06 6.055245319323e-01
+ 9.923000000000e-06 6.055855111475e-01
+ 9.924000000000e-06 6.056464903627e-01
+ 9.925000000000e-06 6.057074695780e-01
+ 9.926000000000e-06 6.057684487932e-01
+ 9.927000000000e-06 6.058294280084e-01
+ 9.928000000000e-06 6.058904072236e-01
+ 9.929000000000e-06 6.059513864388e-01
+ 9.930000000000e-06 6.060123656540e-01
+ 9.931000000000e-06 6.060733448693e-01
+ 9.932000000000e-06 6.061343240845e-01
+ 9.933000000000e-06 6.061953032997e-01
+ 9.934000000000e-06 6.062562825149e-01
+ 9.935000000000e-06 6.063172617301e-01
+ 9.936000000000e-06 6.063782409453e-01
+ 9.937000000000e-06 6.064392201606e-01
+ 9.938000000000e-06 6.065001993758e-01
+ 9.939000000000e-06 6.065611785910e-01
+ 9.940000000000e-06 6.066221578062e-01
+ 9.941000000000e-06 6.066831370214e-01
+ 9.942000000000e-06 6.067441162366e-01
+ 9.943000000000e-06 6.068050954519e-01
+ 9.944000000000e-06 6.068660746671e-01
+ 9.945000000000e-06 6.069270538823e-01
+ 9.946000000000e-06 6.069880330975e-01
+ 9.947000000000e-06 6.070490123127e-01
+ 9.948000000000e-06 6.071099915279e-01
+ 9.949000000000e-06 6.071709707432e-01
+ 9.950000000000e-06 6.072319499584e-01
+ 9.951000000000e-06 6.072929291736e-01
+ 9.952000000000e-06 6.073539083888e-01
+ 9.953000000000e-06 6.074148876040e-01
+ 9.954000000000e-06 6.074758668192e-01
+ 9.955000000000e-06 6.075368460345e-01
+ 9.956000000000e-06 6.075978252497e-01
+ 9.957000000000e-06 6.076588044649e-01
+ 9.958000000000e-06 6.077197836801e-01
+ 9.959000000000e-06 6.077807628953e-01
+ 9.960000000000e-06 6.078417421105e-01
+ 9.961000000000e-06 6.079027213258e-01
+ 9.962000000000e-06 6.079637005410e-01
+ 9.963000000000e-06 6.080246797562e-01
+ 9.964000000000e-06 6.080856589714e-01
+ 9.965000000000e-06 6.081466381866e-01
+ 9.966000000000e-06 6.082076174018e-01
+ 9.967000000000e-06 6.082685966171e-01
+ 9.968000000000e-06 6.083295758323e-01
+ 9.969000000000e-06 6.083905550475e-01
+ 9.970000000000e-06 6.084515342627e-01
+ 9.971000000000e-06 6.085125134779e-01
+ 9.972000000000e-06 6.085734926931e-01
+ 9.973000000000e-06 6.086344719084e-01
+ 9.974000000000e-06 6.086954511236e-01
+ 9.975000000000e-06 6.087564303388e-01
+ 9.976000000000e-06 6.088174095540e-01
+ 9.977000000000e-06 6.088783887692e-01
+ 9.978000000000e-06 6.089393679844e-01
+ 9.979000000000e-06 6.090003471997e-01
+ 9.980000000000e-06 6.090613264149e-01
+ 9.981000000000e-06 6.091223056301e-01
+ 9.982000000000e-06 6.091832848453e-01
+ 9.983000000000e-06 6.092442640605e-01
+ 9.984000000000e-06 6.093052432757e-01
+ 9.985000000000e-06 6.093662224910e-01
+ 9.986000000000e-06 6.094272017062e-01
+ 9.987000000000e-06 6.094881809214e-01
+ 9.988000000000e-06 6.095491601366e-01
+ 9.989000000000e-06 6.096101393518e-01
+ 9.990000000000e-06 6.096711185670e-01
+ 9.991000000000e-06 6.097320977823e-01
+ 9.992000000000e-06 6.097930769975e-01
+ 9.993000000000e-06 6.098540562127e-01
+ 9.994000000000e-06 6.099150354279e-01
+ 9.995000000000e-06 6.099760146431e-01
+ 9.996000000000e-06 6.100369938583e-01
+ 9.997000000000e-06 6.100979730736e-01
+ 9.998000000000e-06 6.101589522888e-01
+ 9.999000000000e-06 6.102199315040e-01
+ 1.000000000000e-05 6.102809107192e-01
+ 1.000100000000e-05 6.103418899344e-01
+ 1.000200000000e-05 6.104028691496e-01
+ 1.000300000000e-05 6.104638483649e-01
+ 1.000400000000e-05 6.105248275801e-01
+ 1.000500000000e-05 6.105858067953e-01
+ 1.000600000000e-05 6.106467860105e-01
+ 1.000700000000e-05 6.107077652257e-01
+ 1.000800000000e-05 6.107687444409e-01
+ 1.000900000000e-05 6.108297236562e-01
+ 1.001000000000e-05 6.108907028714e-01
+ 1.001100000000e-05 6.109516820866e-01
+ 1.001200000000e-05 6.110126613018e-01
+ 1.001300000000e-05 6.110736405170e-01
+ 1.001400000000e-05 6.111346197322e-01
+ 1.001500000000e-05 6.111955989475e-01
+ 1.001600000000e-05 6.112565781627e-01
+ 1.001700000000e-05 6.113175573779e-01
+ 1.001800000000e-05 6.113785365931e-01
+ 1.001900000000e-05 6.114395158083e-01
+ 1.002000000000e-05 6.115004950235e-01
+ 1.002100000000e-05 6.115614742388e-01
+ 1.002200000000e-05 6.116224534540e-01
+ 1.002300000000e-05 6.116834326692e-01
+ 1.002400000000e-05 6.117444118844e-01
+ 1.002500000000e-05 6.118053910996e-01
+ 1.002600000000e-05 6.118663703148e-01
+ 1.002700000000e-05 6.119273495301e-01
+ 1.002800000000e-05 6.119883287453e-01
+ 1.002900000000e-05 6.120493079605e-01
+ 1.003000000000e-05 6.121102871757e-01
+ 1.003100000000e-05 6.121712663909e-01
+ 1.003200000000e-05 6.122322456061e-01
+ 1.003300000000e-05 6.122932248214e-01
+ 1.003400000000e-05 6.123542040366e-01
+ 1.003500000000e-05 6.124151832518e-01
+ 1.003600000000e-05 6.124761624670e-01
+ 1.003700000000e-05 6.125371416822e-01
+ 1.003800000000e-05 6.125981208974e-01
+ 1.003900000000e-05 6.126591001127e-01
+ 1.004000000000e-05 6.127200793279e-01
+ 1.004100000000e-05 6.127810585431e-01
+ 1.004200000000e-05 6.128420377583e-01
+ 1.004300000000e-05 6.129030169735e-01
+ 1.004400000000e-05 6.129639961887e-01
+ 1.004500000000e-05 6.130249754040e-01
+ 1.004600000000e-05 6.130859546192e-01
+ 1.004700000000e-05 6.131469338344e-01
+ 1.004800000000e-05 6.132079130496e-01
+ 1.004900000000e-05 6.132688922648e-01
+ 1.005000000000e-05 6.133298714800e-01
+ 1.005100000000e-05 6.133908506953e-01
+ 1.005200000000e-05 6.134518299105e-01
+ 1.005300000000e-05 6.135128091257e-01
+ 1.005400000000e-05 6.135737883409e-01
+ 1.005500000000e-05 6.136347675561e-01
+ 1.005600000000e-05 6.136957467713e-01
+ 1.005700000000e-05 6.137567259866e-01
+ 1.005800000000e-05 6.138177052018e-01
+ 1.005900000000e-05 6.138786844170e-01
+ 1.006000000000e-05 6.139396636322e-01
+ 1.006100000000e-05 6.140006428474e-01
+ 1.006200000000e-05 6.140616220626e-01
+ 1.006300000000e-05 6.141226012779e-01
+ 1.006400000000e-05 6.141835804931e-01
+ 1.006500000000e-05 6.142445597083e-01
+ 1.006600000000e-05 6.143055389235e-01
+ 1.006700000000e-05 6.143665181387e-01
+ 1.006800000000e-05 6.144274973539e-01
+ 1.006900000000e-05 6.144884765692e-01
+ 1.007000000000e-05 6.145494557844e-01
+ 1.007100000000e-05 6.146104349996e-01
+ 1.007200000000e-05 6.146714142148e-01
+ 1.007300000000e-05 6.147323934300e-01
+ 1.007400000000e-05 6.147933726452e-01
+ 1.007500000000e-05 6.148543518605e-01
+ 1.007600000000e-05 6.149153310757e-01
+ 1.007700000000e-05 6.149763102909e-01
+ 1.007800000000e-05 6.150372895061e-01
+ 1.007900000000e-05 6.150982687213e-01
+ 1.008000000000e-05 6.151592479365e-01
+ 1.008100000000e-05 6.152202271518e-01
+ 1.008200000000e-05 6.152812063670e-01
+ 1.008300000000e-05 6.153421855822e-01
+ 1.008400000000e-05 6.154031647974e-01
+ 1.008500000000e-05 6.154641440126e-01
+ 1.008600000000e-05 6.155251232278e-01
+ 1.008700000000e-05 6.155861024431e-01
+ 1.008800000000e-05 6.156470816583e-01
+ 1.008900000000e-05 6.157080608735e-01
+ 1.009000000000e-05 6.157690400887e-01
+ 1.009100000000e-05 6.158300193039e-01
+ 1.009200000000e-05 6.158909985191e-01
+ 1.009300000000e-05 6.159519777344e-01
+ 1.009400000000e-05 6.160129569496e-01
+ 1.009500000000e-05 6.160739361648e-01
+ 1.009600000000e-05 6.161349153800e-01
+ 1.009700000000e-05 6.161958945952e-01
+ 1.009800000000e-05 6.162568738104e-01
+ 1.009900000000e-05 6.163178530257e-01
+ 1.010000000000e-05 6.163788322409e-01
+ 1.010100000000e-05 6.164398114561e-01
+ 1.010200000000e-05 6.165007906713e-01
+ 1.010300000000e-05 6.165617698865e-01
+ 1.010400000000e-05 6.166227491017e-01
+ 1.010500000000e-05 6.166837283170e-01
+ 1.010600000000e-05 6.167447075322e-01
+ 1.010700000000e-05 6.168056867474e-01
+ 1.010800000000e-05 6.168666659626e-01
+ 1.010900000000e-05 6.169276451778e-01
+ 1.011000000000e-05 6.169886243930e-01
+ 1.011100000000e-05 6.170496036083e-01
+ 1.011200000000e-05 6.171105828235e-01
+ 1.011300000000e-05 6.171715620387e-01
+ 1.011400000000e-05 6.172325412539e-01
+ 1.011500000000e-05 6.172935204691e-01
+ 1.011600000000e-05 6.173544996843e-01
+ 1.011700000000e-05 6.174154788996e-01
+ 1.011800000000e-05 6.174764581148e-01
+ 1.011900000000e-05 6.175374373300e-01
+ 1.012000000000e-05 6.175984165452e-01
+ 1.012100000000e-05 6.176593957604e-01
+ 1.012200000000e-05 6.177203749756e-01
+ 1.012300000000e-05 6.177813541909e-01
+ 1.012400000000e-05 6.178423334061e-01
+ 1.012500000000e-05 6.179033126213e-01
+ 1.012600000000e-05 6.179642918365e-01
+ 1.012700000000e-05 6.180252710517e-01
+ 1.012800000000e-05 6.180862502669e-01
+ 1.012900000000e-05 6.181472294821e-01
+ 1.013000000000e-05 6.182082086974e-01
+ 1.013100000000e-05 6.182691879126e-01
+ 1.013200000000e-05 6.183301671278e-01
+ 1.013300000000e-05 6.183911463430e-01
+ 1.013400000000e-05 6.184521255582e-01
+ 1.013500000000e-05 6.185131047734e-01
+ 1.013600000000e-05 6.185740839887e-01
+ 1.013700000000e-05 6.186350632039e-01
+ 1.013800000000e-05 6.186960424191e-01
+ 1.013900000000e-05 6.187570216343e-01
+ 1.014000000000e-05 6.188180008495e-01
+ 1.014100000000e-05 6.188789800647e-01
+ 1.014200000000e-05 6.189399592800e-01
+ 1.014300000000e-05 6.190009384952e-01
+ 1.014400000000e-05 6.190619177104e-01
+ 1.014500000000e-05 6.191228969256e-01
+ 1.014600000000e-05 6.191838761408e-01
+ 1.014700000000e-05 6.192448553560e-01
+ 1.014800000000e-05 6.193058345713e-01
+ 1.014900000000e-05 6.193668137865e-01
+ 1.015000000000e-05 6.194277930017e-01
+ 1.015100000000e-05 6.194887722169e-01
+ 1.015200000000e-05 6.195497514321e-01
+ 1.015300000000e-05 6.196107306473e-01
+ 1.015400000000e-05 6.196717098626e-01
+ 1.015500000000e-05 6.197326890778e-01
+ 1.015600000000e-05 6.197936682930e-01
+ 1.015700000000e-05 6.198546475082e-01
+ 1.015800000000e-05 6.199156267234e-01
+ 1.015900000000e-05 6.199766059386e-01
+ 1.016000000000e-05 6.200375851539e-01
+ 1.016100000000e-05 6.200985643691e-01
+ 1.016200000000e-05 6.201595435843e-01
+ 1.016300000000e-05 6.202205227995e-01
+ 1.016400000000e-05 6.202815020147e-01
+ 1.016500000000e-05 6.203424812299e-01
+ 1.016600000000e-05 6.204034604452e-01
+ 1.016700000000e-05 6.204644396604e-01
+ 1.016800000000e-05 6.205254188756e-01
+ 1.016900000000e-05 6.205863980908e-01
+ 1.017000000000e-05 6.206473773060e-01
+ 1.017100000000e-05 6.207083565212e-01
+ 1.017200000000e-05 6.207693357365e-01
+ 1.017300000000e-05 6.208303149517e-01
+ 1.017400000000e-05 6.208912941669e-01
+ 1.017500000000e-05 6.209522733821e-01
+ 1.017600000000e-05 6.210132525973e-01
+ 1.017700000000e-05 6.210742318125e-01
+ 1.017800000000e-05 6.211352110278e-01
+ 1.017900000000e-05 6.211961902430e-01
+ 1.018000000000e-05 6.212571694582e-01
+ 1.018100000000e-05 6.213181486734e-01
+ 1.018200000000e-05 6.213791278886e-01
+ 1.018300000000e-05 6.214401071038e-01
+ 1.018400000000e-05 6.215010863191e-01
+ 1.018500000000e-05 6.215620655343e-01
+ 1.018600000000e-05 6.216230447495e-01
+ 1.018700000000e-05 6.216840239647e-01
+ 1.018800000000e-05 6.217450031799e-01
+ 1.018900000000e-05 6.218059823951e-01
+ 1.019000000000e-05 6.218669616104e-01
+ 1.019100000000e-05 6.219279408256e-01
+ 1.019200000000e-05 6.219889200408e-01
+ 1.019300000000e-05 6.220498992560e-01
+ 1.019400000000e-05 6.221108784712e-01
+ 1.019500000000e-05 6.221718576864e-01
+ 1.019600000000e-05 6.222328369017e-01
+ 1.019700000000e-05 6.222938161169e-01
+ 1.019800000000e-05 6.223547953321e-01
+ 1.019900000000e-05 6.224157745473e-01
+ 1.020000000000e-05 6.224767537625e-01
+ 1.020100000000e-05 6.225377329777e-01
+ 1.020200000000e-05 6.225987121930e-01
+ 1.020300000000e-05 6.226596914082e-01
+ 1.020400000000e-05 6.227206706234e-01
+ 1.020500000000e-05 6.227816498386e-01
+ 1.020600000000e-05 6.228426290538e-01
+ 1.020700000000e-05 6.229036082690e-01
+ 1.020800000000e-05 6.229645874843e-01
+ 1.020900000000e-05 6.230255666995e-01
+ 1.021000000000e-05 6.230865459147e-01
+ 1.021100000000e-05 6.231475251299e-01
+ 1.021200000000e-05 6.232085043451e-01
+ 1.021300000000e-05 6.232694835603e-01
+ 1.021400000000e-05 6.233304627756e-01
+ 1.021500000000e-05 6.233914419908e-01
+ 1.021600000000e-05 6.234524212060e-01
+ 1.021700000000e-05 6.235134004212e-01
+ 1.021800000000e-05 6.235743796364e-01
+ 1.021900000000e-05 6.236353588516e-01
+ 1.022000000000e-05 6.236963380669e-01
+ 1.022100000000e-05 6.237573172821e-01
+ 1.022200000000e-05 6.238182964973e-01
+ 1.022300000000e-05 6.238792757125e-01
+ 1.022400000000e-05 6.239402549277e-01
+ 1.022500000000e-05 6.240012341429e-01
+ 1.022600000000e-05 6.240622133582e-01
+ 1.022700000000e-05 6.241231925734e-01
+ 1.022800000000e-05 6.241841717886e-01
+ 1.022900000000e-05 6.242451510038e-01
+ 1.023000000000e-05 6.243061302190e-01
+ 1.023100000000e-05 6.243671094342e-01
+ 1.023200000000e-05 6.244280886495e-01
+ 1.023300000000e-05 6.244890678647e-01
+ 1.023400000000e-05 6.245500470799e-01
+ 1.023500000000e-05 6.246110262951e-01
+ 1.023600000000e-05 6.246720055103e-01
+ 1.023700000000e-05 6.247329847255e-01
+ 1.023800000000e-05 6.247939639408e-01
+ 1.023900000000e-05 6.248549431560e-01
+ 1.024000000000e-05 6.249159223712e-01
+ 1.024100000000e-05 6.249769015864e-01
+ 1.024200000000e-05 6.250378808016e-01
+ 1.024300000000e-05 6.250988600168e-01
+ 1.024400000000e-05 6.251598392321e-01
+ 1.024500000000e-05 6.252208184473e-01
+ 1.024600000000e-05 6.252817976625e-01
+ 1.024700000000e-05 6.253427768777e-01
+ 1.024800000000e-05 6.254037560929e-01
+ 1.024900000000e-05 6.254647353081e-01
+ 1.025000000000e-05 6.255257145234e-01
+ 1.025100000000e-05 6.255866937386e-01
+ 1.025200000000e-05 6.256476729538e-01
+ 1.025300000000e-05 6.257086521690e-01
+ 1.025400000000e-05 6.257696313842e-01
+ 1.025500000000e-05 6.258306105994e-01
+ 1.025600000000e-05 6.258915898147e-01
+ 1.025700000000e-05 6.259525690299e-01
+ 1.025800000000e-05 6.260135482451e-01
+ 1.025900000000e-05 6.260745274603e-01
+ 1.026000000000e-05 6.261355066755e-01
+ 1.026100000000e-05 6.261964858907e-01
+ 1.026200000000e-05 6.262574651060e-01
+ 1.026300000000e-05 6.263184443212e-01
+ 1.026400000000e-05 6.263794235364e-01
+ 1.026500000000e-05 6.264404027516e-01
+ 1.026600000000e-05 6.265013819668e-01
+ 1.026700000000e-05 6.265623611820e-01
+ 1.026800000000e-05 6.266233403973e-01
+ 1.026900000000e-05 6.266843196125e-01
+ 1.027000000000e-05 6.267452988277e-01
+ 1.027100000000e-05 6.268062780429e-01
+ 1.027200000000e-05 6.268672572581e-01
+ 1.027300000000e-05 6.269282364733e-01
+ 1.027400000000e-05 6.269892156886e-01
+ 1.027500000000e-05 6.270501949038e-01
+ 1.027600000000e-05 6.271111741190e-01
+ 1.027700000000e-05 6.271721533342e-01
+ 1.027800000000e-05 6.272331325494e-01
+ 1.027900000000e-05 6.272941117646e-01
+ 1.028000000000e-05 6.273550909799e-01
+ 1.028100000000e-05 6.274160701951e-01
+ 1.028200000000e-05 6.274770494103e-01
+ 1.028300000000e-05 6.275380286255e-01
+ 1.028400000000e-05 6.275990078407e-01
+ 1.028500000000e-05 6.276599870559e-01
+ 1.028600000000e-05 6.277209662712e-01
+ 1.028700000000e-05 6.277819454864e-01
+ 1.028800000000e-05 6.278429247016e-01
+ 1.028900000000e-05 6.279039039168e-01
+ 1.029000000000e-05 6.279648831320e-01
+ 1.029100000000e-05 6.280258623472e-01
+ 1.029200000000e-05 6.280868415625e-01
+ 1.029300000000e-05 6.281478207777e-01
+ 1.029400000000e-05 6.282087999929e-01
+ 1.029500000000e-05 6.282697792081e-01
+ 1.029600000000e-05 6.283307584233e-01
+ 1.029700000000e-05 6.283917376385e-01
+ 1.029800000000e-05 6.284527168538e-01
+ 1.029900000000e-05 6.285136960690e-01
+ 1.030000000000e-05 6.285746752842e-01
+ 1.030100000000e-05 6.286356544994e-01
+ 1.030200000000e-05 6.286966337146e-01
+ 1.030300000000e-05 6.287576129298e-01
+ 1.030400000000e-05 6.288185921451e-01
+ 1.030500000000e-05 6.288795713603e-01
+ 1.030600000000e-05 6.289405505755e-01
+ 1.030700000000e-05 6.290015297907e-01
+ 1.030800000000e-05 6.290625090059e-01
+ 1.030900000000e-05 6.291234882211e-01
+ 1.031000000000e-05 6.291844674364e-01
+ 1.031100000000e-05 6.292454466516e-01
+ 1.031200000000e-05 6.293064258668e-01
+ 1.031300000000e-05 6.293674050820e-01
+ 1.031400000000e-05 6.294283842972e-01
+ 1.031500000000e-05 6.294893635124e-01
+ 1.031600000000e-05 6.295503427277e-01
+ 1.031700000000e-05 6.296113219429e-01
+ 1.031800000000e-05 6.296723011581e-01
+ 1.031900000000e-05 6.297332803733e-01
+ 1.032000000000e-05 6.297942595885e-01
+ 1.032100000000e-05 6.298552388037e-01
+ 1.032200000000e-05 6.299162180190e-01
+ 1.032300000000e-05 6.299771972342e-01
+ 1.032400000000e-05 6.300381764494e-01
+ 1.032500000000e-05 6.300991556646e-01
+ 1.032600000000e-05 6.301601348798e-01
+ 1.032700000000e-05 6.302211140950e-01
+ 1.032800000000e-05 6.302820933103e-01
+ 1.032900000000e-05 6.303430725255e-01
+ 1.033000000000e-05 6.304040517407e-01
+ 1.033100000000e-05 6.304650309559e-01
+ 1.033200000000e-05 6.305260101711e-01
+ 1.033300000000e-05 6.305869893863e-01
+ 1.033400000000e-05 6.306479686016e-01
+ 1.033500000000e-05 6.307089478168e-01
+ 1.033600000000e-05 6.307699270320e-01
+ 1.033700000000e-05 6.308309062472e-01
+ 1.033800000000e-05 6.308918854624e-01
+ 1.033900000000e-05 6.309528646776e-01
+ 1.034000000000e-05 6.310138438929e-01
+ 1.034100000000e-05 6.310748231081e-01
+ 1.034200000000e-05 6.311358023233e-01
+ 1.034300000000e-05 6.311967815385e-01
+ 1.034400000000e-05 6.312577607537e-01
+ 1.034500000000e-05 6.313187399689e-01
+ 1.034600000000e-05 6.313797191842e-01
+ 1.034700000000e-05 6.314406983994e-01
+ 1.034800000000e-05 6.315016776146e-01
+ 1.034900000000e-05 6.315626568298e-01
+ 1.035000000000e-05 6.316236360450e-01
+ 1.035100000000e-05 6.316846152602e-01
+ 1.035200000000e-05 6.317455944755e-01
+ 1.035300000000e-05 6.318065736907e-01
+ 1.035400000000e-05 6.318675529059e-01
+ 1.035500000000e-05 6.319285321211e-01
+ 1.035600000000e-05 6.319895113363e-01
+ 1.035700000000e-05 6.320504905515e-01
+ 1.035800000000e-05 6.321114697667e-01
+ 1.035900000000e-05 6.321724489820e-01
+ 1.036000000000e-05 6.322334281972e-01
+ 1.036100000000e-05 6.322944074124e-01
+ 1.036200000000e-05 6.323553866276e-01
+ 1.036300000000e-05 6.324163658428e-01
+ 1.036400000000e-05 6.324773450580e-01
+ 1.036500000000e-05 6.325383242733e-01
+ 1.036600000000e-05 6.325993034885e-01
+ 1.036700000000e-05 6.326602827037e-01
+ 1.036800000000e-05 6.327212619189e-01
+ 1.036900000000e-05 6.327822411341e-01
+ 1.037000000000e-05 6.328432203493e-01
+ 1.037100000000e-05 6.329041995646e-01
+ 1.037200000000e-05 6.329651787798e-01
+ 1.037300000000e-05 6.330261579950e-01
+ 1.037400000000e-05 6.330871372102e-01
+ 1.037500000000e-05 6.331481164254e-01
+ 1.037600000000e-05 6.332090956406e-01
+ 1.037700000000e-05 6.332700748559e-01
+ 1.037800000000e-05 6.333310540711e-01
+ 1.037900000000e-05 6.333920332863e-01
+ 1.038000000000e-05 6.334530125015e-01
+ 1.038100000000e-05 6.335139917167e-01
+ 1.038200000000e-05 6.335749709319e-01
+ 1.038300000000e-05 6.336359501472e-01
+ 1.038400000000e-05 6.336969293624e-01
+ 1.038500000000e-05 6.337579085776e-01
+ 1.038600000000e-05 6.338188877928e-01
+ 1.038700000000e-05 6.338798670080e-01
+ 1.038800000000e-05 6.339408462232e-01
+ 1.038900000000e-05 6.340018254385e-01
+ 1.039000000000e-05 6.340628046537e-01
+ 1.039100000000e-05 6.341237838689e-01
+ 1.039200000000e-05 6.341847630841e-01
+ 1.039300000000e-05 6.342457422993e-01
+ 1.039400000000e-05 6.343067215145e-01
+ 1.039500000000e-05 6.343677007298e-01
+ 1.039600000000e-05 6.344286799450e-01
+ 1.039700000000e-05 6.344896591602e-01
+ 1.039800000000e-05 6.345506383754e-01
+ 1.039900000000e-05 6.346116175906e-01
+ 1.040000000000e-05 6.346725968058e-01
+ 1.040100000000e-05 6.347335760211e-01
+ 1.040200000000e-05 6.347945552363e-01
+ 1.040300000000e-05 6.348555344515e-01
+ 1.040400000000e-05 6.349165136667e-01
+ 1.040500000000e-05 6.349774928819e-01
+ 1.040600000000e-05 6.350384720971e-01
+ 1.040700000000e-05 6.350994513124e-01
+ 1.040800000000e-05 6.351604305276e-01
+ 1.040900000000e-05 6.352214097428e-01
+ 1.041000000000e-05 6.352823889580e-01
+ 1.041100000000e-05 6.353433681732e-01
+ 1.041200000000e-05 6.354043473884e-01
+ 1.041300000000e-05 6.354653266037e-01
+ 1.041400000000e-05 6.355263058189e-01
+ 1.041500000000e-05 6.355872850341e-01
+ 1.041600000000e-05 6.356482642493e-01
+ 1.041700000000e-05 6.357092434645e-01
+ 1.041800000000e-05 6.357702226797e-01
+ 1.041900000000e-05 6.358312018950e-01
+ 1.042000000000e-05 6.358921811102e-01
+ 1.042100000000e-05 6.359531603254e-01
+ 1.042200000000e-05 6.360141395406e-01
+ 1.042300000000e-05 6.360751187558e-01
+ 1.042400000000e-05 6.361360979710e-01
+ 1.042500000000e-05 6.361970771863e-01
+ 1.042600000000e-05 6.362580564015e-01
+ 1.042700000000e-05 6.363190356167e-01
+ 1.042800000000e-05 6.363800148319e-01
+ 1.042900000000e-05 6.364409940471e-01
+ 1.043000000000e-05 6.365019732623e-01
+ 1.043100000000e-05 6.365629524776e-01
+ 1.043200000000e-05 6.366239316928e-01
+ 1.043300000000e-05 6.366849109080e-01
+ 1.043400000000e-05 6.367458901232e-01
+ 1.043500000000e-05 6.368068693384e-01
+ 1.043600000000e-05 6.368678485536e-01
+ 1.043700000000e-05 6.369288277689e-01
+ 1.043800000000e-05 6.369898069841e-01
+ 1.043900000000e-05 6.370507861993e-01
+ 1.044000000000e-05 6.371117654145e-01
+ 1.044100000000e-05 6.371727446297e-01
+ 1.044200000000e-05 6.372337238449e-01
+ 1.044300000000e-05 6.372947030602e-01
+ 1.044400000000e-05 6.373556822754e-01
+ 1.044500000000e-05 6.374166614906e-01
+ 1.044600000000e-05 6.374776407058e-01
+ 1.044700000000e-05 6.375386199210e-01
+ 1.044800000000e-05 6.375995991362e-01
+ 1.044900000000e-05 6.376605783515e-01
+ 1.045000000000e-05 6.377215575667e-01
+ 1.045100000000e-05 6.377825367819e-01
+ 1.045200000000e-05 6.378435159971e-01
+ 1.045300000000e-05 6.379044952123e-01
+ 1.045400000000e-05 6.379654744275e-01
+ 1.045500000000e-05 6.380264536428e-01
+ 1.045600000000e-05 6.380874328580e-01
+ 1.045700000000e-05 6.381484120732e-01
+ 1.045800000000e-05 6.382093912884e-01
+ 1.045900000000e-05 6.382703705036e-01
+ 1.046000000000e-05 6.383313497188e-01
+ 1.046100000000e-05 6.383923289341e-01
+ 1.046200000000e-05 6.384533081493e-01
+ 1.046300000000e-05 6.385142873645e-01
+ 1.046400000000e-05 6.385752665797e-01
+ 1.046500000000e-05 6.386362457949e-01
+ 1.046600000000e-05 6.386972250101e-01
+ 1.046700000000e-05 6.387582042254e-01
+ 1.046800000000e-05 6.388191834406e-01
+ 1.046900000000e-05 6.388801626558e-01
+ 1.047000000000e-05 6.389411418710e-01
+ 1.047100000000e-05 6.390021210862e-01
+ 1.047200000000e-05 6.390631003014e-01
+ 1.047300000000e-05 6.391240795167e-01
+ 1.047400000000e-05 6.391850587319e-01
+ 1.047500000000e-05 6.392460379471e-01
+ 1.047600000000e-05 6.393070171623e-01
+ 1.047700000000e-05 6.393679963775e-01
+ 1.047800000000e-05 6.394289755927e-01
+ 1.047900000000e-05 6.394899548080e-01
+ 1.048000000000e-05 6.395509340232e-01
+ 1.048100000000e-05 6.396119132384e-01
+ 1.048200000000e-05 6.396728924536e-01
+ 1.048300000000e-05 6.397338716688e-01
+ 1.048400000000e-05 6.397948508840e-01
+ 1.048500000000e-05 6.398558300993e-01
+ 1.048600000000e-05 6.399168093145e-01
+ 1.048700000000e-05 6.399777885297e-01
+ 1.048800000000e-05 6.400387677449e-01
+ 1.048900000000e-05 6.400997469601e-01
+ 1.049000000000e-05 6.401607261753e-01
+ 1.049100000000e-05 6.402217053906e-01
+ 1.049200000000e-05 6.402826846058e-01
+ 1.049300000000e-05 6.403436638210e-01
+ 1.049400000000e-05 6.404046430362e-01
+ 1.049500000000e-05 6.404656222514e-01
+ 1.049600000000e-05 6.405266014666e-01
+ 1.049700000000e-05 6.405875806819e-01
+ 1.049800000000e-05 6.406485598971e-01
+ 1.049900000000e-05 6.407095391123e-01
+ 1.050000000000e-05 6.407705183275e-01
+ 1.050100000000e-05 6.408314975427e-01
+ 1.050200000000e-05 6.408924767579e-01
+ 1.050300000000e-05 6.409534559732e-01
+ 1.050400000000e-05 6.410144351884e-01
+ 1.050500000000e-05 6.410754144036e-01
+ 1.050600000000e-05 6.411363936188e-01
+ 1.050700000000e-05 6.411973728340e-01
+ 1.050800000000e-05 6.412583520492e-01
+ 1.050900000000e-05 6.413193312645e-01
+ 1.051000000000e-05 6.413803104797e-01
+ 1.051100000000e-05 6.414412896949e-01
+ 1.051200000000e-05 6.415022689101e-01
+ 1.051300000000e-05 6.415632481253e-01
+ 1.051400000000e-05 6.416242273405e-01
+ 1.051500000000e-05 6.416852065558e-01
+ 1.051600000000e-05 6.417461857710e-01
+ 1.051700000000e-05 6.418071649862e-01
+ 1.051800000000e-05 6.418681442014e-01
+ 1.051900000000e-05 6.419291234166e-01
+ 1.052000000000e-05 6.419901026318e-01
+ 1.052100000000e-05 6.420510818471e-01
+ 1.052200000000e-05 6.421120610623e-01
+ 1.052300000000e-05 6.421730402775e-01
+ 1.052400000000e-05 6.422340194927e-01
+ 1.052500000000e-05 6.422949987079e-01
+ 1.052600000000e-05 6.423559779231e-01
+ 1.052700000000e-05 6.424169571384e-01
+ 1.052800000000e-05 6.424779363536e-01
+ 1.052900000000e-05 6.425389155688e-01
+ 1.053000000000e-05 6.425998947840e-01
+ 1.053100000000e-05 6.426608739992e-01
+ 1.053200000000e-05 6.427218532144e-01
+ 1.053300000000e-05 6.427828324297e-01
+ 1.053400000000e-05 6.428438116449e-01
+ 1.053500000000e-05 6.429047908601e-01
+ 1.053600000000e-05 6.429657700753e-01
+ 1.053700000000e-05 6.430267492905e-01
+ 1.053800000000e-05 6.430877285057e-01
+ 1.053900000000e-05 6.431487077210e-01
+ 1.054000000000e-05 6.432096869362e-01
+ 1.054100000000e-05 6.432706661514e-01
+ 1.054200000000e-05 6.433316453666e-01
+ 1.054300000000e-05 6.433926245818e-01
+ 1.054400000000e-05 6.434536037970e-01
+ 1.054500000000e-05 6.435145830123e-01
+ 1.054600000000e-05 6.435755622275e-01
+ 1.054700000000e-05 6.436365414427e-01
+ 1.054800000000e-05 6.436975206579e-01
+ 1.054900000000e-05 6.437584998731e-01
+ 1.055000000000e-05 6.438194790883e-01
+ 1.055100000000e-05 6.438804583036e-01
+ 1.055200000000e-05 6.439414375188e-01
+ 1.055300000000e-05 6.440024167340e-01
+ 1.055400000000e-05 6.440633959492e-01
+ 1.055500000000e-05 6.441243751644e-01
+ 1.055600000000e-05 6.441853543796e-01
+ 1.055700000000e-05 6.442463335949e-01
+ 1.055800000000e-05 6.443073128101e-01
+ 1.055900000000e-05 6.443682920253e-01
+ 1.056000000000e-05 6.444292712405e-01
+ 1.056100000000e-05 6.444902504557e-01
+ 1.056200000000e-05 6.445512296709e-01
+ 1.056300000000e-05 6.446122088862e-01
+ 1.056400000000e-05 6.446731881014e-01
+ 1.056500000000e-05 6.447341673166e-01
+ 1.056600000000e-05 6.447951465318e-01
+ 1.056700000000e-05 6.448561257470e-01
+ 1.056800000000e-05 6.449171049622e-01
+ 1.056900000000e-05 6.449780841775e-01
+ 1.057000000000e-05 6.450390633927e-01
+ 1.057100000000e-05 6.451000426079e-01
+ 1.057200000000e-05 6.451610218231e-01
+ 1.057300000000e-05 6.452220010383e-01
+ 1.057400000000e-05 6.452829802535e-01
+ 1.057500000000e-05 6.453439594688e-01
+ 1.057600000000e-05 6.454049386840e-01
+ 1.057700000000e-05 6.454659178992e-01
+ 1.057800000000e-05 6.455268971144e-01
+ 1.057900000000e-05 6.455878763296e-01
+ 1.058000000000e-05 6.456488555448e-01
+ 1.058100000000e-05 6.457098347601e-01
+ 1.058200000000e-05 6.457708139753e-01
+ 1.058300000000e-05 6.458317931905e-01
+ 1.058400000000e-05 6.458927724057e-01
+ 1.058500000000e-05 6.459537516209e-01
+ 1.058600000000e-05 6.460147308361e-01
+ 1.058700000000e-05 6.460757100513e-01
+ 1.058800000000e-05 6.461366892666e-01
+ 1.058900000000e-05 6.461976684818e-01
+ 1.059000000000e-05 6.462586476970e-01
+ 1.059100000000e-05 6.463196269122e-01
+ 1.059200000000e-05 6.463806061274e-01
+ 1.059300000000e-05 6.464415853426e-01
+ 1.059400000000e-05 6.465025645579e-01
+ 1.059500000000e-05 6.465635437731e-01
+ 1.059600000000e-05 6.466245229883e-01
+ 1.059700000000e-05 6.466855022035e-01
+ 1.059800000000e-05 6.467464814187e-01
+ 1.059900000000e-05 6.468074606339e-01
+ 1.060000000000e-05 6.468684398492e-01
+ 1.060100000000e-05 6.469294190644e-01
+ 1.060200000000e-05 6.469903982796e-01
+ 1.060300000000e-05 6.470513774948e-01
+ 1.060400000000e-05 6.471123567100e-01
+ 1.060500000000e-05 6.471733359252e-01
+ 1.060600000000e-05 6.472343151405e-01
+ 1.060700000000e-05 6.472952943557e-01
+ 1.060800000000e-05 6.473562735709e-01
+ 1.060900000000e-05 6.474172527861e-01
+ 1.061000000000e-05 6.474782320013e-01
+ 1.061100000000e-05 6.475392112165e-01
+ 1.061200000000e-05 6.476001904318e-01
+ 1.061300000000e-05 6.476611696470e-01
+ 1.061400000000e-05 6.477221488622e-01
+ 1.061500000000e-05 6.477831280774e-01
+ 1.061600000000e-05 6.478441072926e-01
+ 1.061700000000e-05 6.479050865078e-01
+ 1.061800000000e-05 6.479660657231e-01
+ 1.061900000000e-05 6.480270449383e-01
+ 1.062000000000e-05 6.480880241535e-01
+ 1.062100000000e-05 6.481490033687e-01
+ 1.062200000000e-05 6.482099825839e-01
+ 1.062300000000e-05 6.482709617991e-01
+ 1.062400000000e-05 6.483319410144e-01
+ 1.062500000000e-05 6.483929202296e-01
+ 1.062600000000e-05 6.484538994448e-01
+ 1.062700000000e-05 6.485148786600e-01
+ 1.062800000000e-05 6.485758578752e-01
+ 1.062900000000e-05 6.486368370904e-01
+ 1.063000000000e-05 6.486978163057e-01
+ 1.063100000000e-05 6.487587955209e-01
+ 1.063200000000e-05 6.488197747361e-01
+ 1.063300000000e-05 6.488807539513e-01
+ 1.063400000000e-05 6.489417331665e-01
+ 1.063500000000e-05 6.490027123817e-01
+ 1.063600000000e-05 6.490636915970e-01
+ 1.063700000000e-05 6.491246708122e-01
+ 1.063800000000e-05 6.491856500274e-01
+ 1.063900000000e-05 6.492466292426e-01
+ 1.064000000000e-05 6.493076084578e-01
+ 1.064100000000e-05 6.493685876730e-01
+ 1.064200000000e-05 6.494295668883e-01
+ 1.064300000000e-05 6.494905461035e-01
+ 1.064400000000e-05 6.495515253187e-01
+ 1.064500000000e-05 6.496125045339e-01
+ 1.064600000000e-05 6.496734837491e-01
+ 1.064700000000e-05 6.497344629643e-01
+ 1.064800000000e-05 6.497954421796e-01
+ 1.064900000000e-05 6.498564213948e-01
+ 1.065000000000e-05 6.499174006100e-01
+ 1.065100000000e-05 6.499783798252e-01
+ 1.065200000000e-05 6.500393590404e-01
+ 1.065300000000e-05 6.501003382556e-01
+ 1.065400000000e-05 6.501613174709e-01
+ 1.065500000000e-05 6.502222966861e-01
+ 1.065600000000e-05 6.502832759013e-01
+ 1.065700000000e-05 6.503442551165e-01
+ 1.065800000000e-05 6.504052343317e-01
+ 1.065900000000e-05 6.504662135469e-01
+ 1.066000000000e-05 6.505271927622e-01
+ 1.066100000000e-05 6.505881719774e-01
+ 1.066200000000e-05 6.506491511926e-01
+ 1.066300000000e-05 6.507101304078e-01
+ 1.066400000000e-05 6.507711096230e-01
+ 1.066500000000e-05 6.508320888382e-01
+ 1.066600000000e-05 6.508930680535e-01
+ 1.066700000000e-05 6.509540472687e-01
+ 1.066800000000e-05 6.510150264839e-01
+ 1.066900000000e-05 6.510760056991e-01
+ 1.067000000000e-05 6.511369849143e-01
+ 1.067100000000e-05 6.511979641295e-01
+ 1.067200000000e-05 6.512589433448e-01
+ 1.067300000000e-05 6.513199225600e-01
+ 1.067400000000e-05 6.513809017752e-01
+ 1.067500000000e-05 6.514418809904e-01
+ 1.067600000000e-05 6.515028602056e-01
+ 1.067700000000e-05 6.515638394208e-01
+ 1.067800000000e-05 6.516248186361e-01
+ 1.067900000000e-05 6.516857978513e-01
+ 1.068000000000e-05 6.517467770665e-01
+ 1.068100000000e-05 6.518077562817e-01
+ 1.068200000000e-05 6.518687354969e-01
+ 1.068300000000e-05 6.519297147121e-01
+ 1.068400000000e-05 6.519906939274e-01
+ 1.068500000000e-05 6.520516731426e-01
+ 1.068600000000e-05 6.521126523578e-01
+ 1.068700000000e-05 6.521736315730e-01
+ 1.068800000000e-05 6.522346107882e-01
+ 1.068900000000e-05 6.522955900034e-01
+ 1.069000000000e-05 6.523565692187e-01
+ 1.069100000000e-05 6.524175484339e-01
+ 1.069200000000e-05 6.524785276491e-01
+ 1.069300000000e-05 6.525395068643e-01
+ 1.069400000000e-05 6.526004860795e-01
+ 1.069500000000e-05 6.526614652947e-01
+ 1.069600000000e-05 6.527224445100e-01
+ 1.069700000000e-05 6.527834237252e-01
+ 1.069800000000e-05 6.528444029404e-01
+ 1.069900000000e-05 6.529053821556e-01
+ 1.070000000000e-05 6.529663613708e-01
+ 1.070100000000e-05 6.530273405860e-01
+ 1.070200000000e-05 6.530883198013e-01
+ 1.070300000000e-05 6.531492990165e-01
+ 1.070400000000e-05 6.532102782317e-01
+ 1.070500000000e-05 6.532712574469e-01
+ 1.070600000000e-05 6.533322366621e-01
+ 1.070700000000e-05 6.533932158773e-01
+ 1.070800000000e-05 6.534541950926e-01
+ 1.070900000000e-05 6.535151743078e-01
+ 1.071000000000e-05 6.535761535230e-01
+ 1.071100000000e-05 6.536371327382e-01
+ 1.071200000000e-05 6.536981119534e-01
+ 1.071300000000e-05 6.537590911686e-01
+ 1.071400000000e-05 6.538200703839e-01
+ 1.071500000000e-05 6.538810495991e-01
+ 1.071600000000e-05 6.539420288143e-01
+ 1.071700000000e-05 6.540030080295e-01
+ 1.071800000000e-05 6.540639872447e-01
+ 1.071900000000e-05 6.541249664599e-01
+ 1.072000000000e-05 6.541859456752e-01
+ 1.072100000000e-05 6.542469248904e-01
+ 1.072200000000e-05 6.543079041056e-01
+ 1.072300000000e-05 6.543688833208e-01
+ 1.072400000000e-05 6.544298625360e-01
+ 1.072500000000e-05 6.544908417512e-01
+ 1.072600000000e-05 6.545518209665e-01
+ 1.072700000000e-05 6.546128001817e-01
+ 1.072800000000e-05 6.546737793969e-01
+ 1.072900000000e-05 6.547347586121e-01
+ 1.073000000000e-05 6.547957378273e-01
+ 1.073100000000e-05 6.548567170425e-01
+ 1.073200000000e-05 6.549176962578e-01
+ 1.073300000000e-05 6.549786754730e-01
+ 1.073400000000e-05 6.550396546882e-01
+ 1.073500000000e-05 6.551006339034e-01
+ 1.073600000000e-05 6.551616131186e-01
+ 1.073700000000e-05 6.552225923338e-01
+ 1.073800000000e-05 6.552835715491e-01
+ 1.073900000000e-05 6.553445507643e-01
+ 1.074000000000e-05 6.554055299795e-01
+ 1.074100000000e-05 6.554665091947e-01
+ 1.074200000000e-05 6.555274884099e-01
+ 1.074300000000e-05 6.555884676251e-01
+ 1.074400000000e-05 6.556494468404e-01
+ 1.074500000000e-05 6.557104260556e-01
+ 1.074600000000e-05 6.557714052708e-01
+ 1.074700000000e-05 6.558323844860e-01
+ 1.074800000000e-05 6.558933637012e-01
+ 1.074900000000e-05 6.559543429164e-01
+ 1.075000000000e-05 6.560153221317e-01
+ 1.075100000000e-05 6.560763013469e-01
+ 1.075200000000e-05 6.561372805621e-01
+ 1.075300000000e-05 6.561982597773e-01
+ 1.075400000000e-05 6.562592389925e-01
+ 1.075500000000e-05 6.563202182077e-01
+ 1.075600000000e-05 6.563811974230e-01
+ 1.075700000000e-05 6.564421766382e-01
+ 1.075800000000e-05 6.565031558534e-01
+ 1.075900000000e-05 6.565641350686e-01
+ 1.076000000000e-05 6.566251142838e-01
+ 1.076100000000e-05 6.566860934990e-01
+ 1.076200000000e-05 6.567470727143e-01
+ 1.076300000000e-05 6.568080519295e-01
+ 1.076400000000e-05 6.568690311447e-01
+ 1.076500000000e-05 6.569300103599e-01
+ 1.076600000000e-05 6.569909895751e-01
+ 1.076700000000e-05 6.570519687903e-01
+ 1.076800000000e-05 6.571129480056e-01
+ 1.076900000000e-05 6.571739272208e-01
+ 1.077000000000e-05 6.572349064360e-01
+ 1.077100000000e-05 6.572958856512e-01
+ 1.077200000000e-05 6.573568648664e-01
+ 1.077300000000e-05 6.574178440816e-01
+ 1.077400000000e-05 6.574788232969e-01
+ 1.077500000000e-05 6.575398025121e-01
+ 1.077600000000e-05 6.576007817273e-01
+ 1.077700000000e-05 6.576617609425e-01
+ 1.077800000000e-05 6.577227401577e-01
+ 1.077900000000e-05 6.577837193729e-01
+ 1.078000000000e-05 6.578446985882e-01
+ 1.078100000000e-05 6.579056778034e-01
+ 1.078200000000e-05 6.579666570186e-01
+ 1.078300000000e-05 6.580276362338e-01
+ 1.078400000000e-05 6.580886154490e-01
+ 1.078500000000e-05 6.581495946642e-01
+ 1.078600000000e-05 6.582105738795e-01
+ 1.078700000000e-05 6.582715530947e-01
+ 1.078800000000e-05 6.583325323099e-01
+ 1.078900000000e-05 6.583935115251e-01
+ 1.079000000000e-05 6.584544907403e-01
+ 1.079100000000e-05 6.585154699555e-01
+ 1.079200000000e-05 6.585764491708e-01
+ 1.079300000000e-05 6.586374283860e-01
+ 1.079400000000e-05 6.586984076012e-01
+ 1.079500000000e-05 6.587593868164e-01
+ 1.079600000000e-05 6.588203660316e-01
+ 1.079700000000e-05 6.588813452468e-01
+ 1.079800000000e-05 6.589423244621e-01
+ 1.079900000000e-05 6.590033036773e-01
+ 1.080000000000e-05 6.590642828925e-01
+ 1.080100000000e-05 6.591252621077e-01
+ 1.080200000000e-05 6.591862413229e-01
+ 1.080300000000e-05 6.592472205381e-01
+ 1.080400000000e-05 6.593081997534e-01
+ 1.080500000000e-05 6.593691789686e-01
+ 1.080600000000e-05 6.594301581838e-01
+ 1.080700000000e-05 6.594911373990e-01
+ 1.080800000000e-05 6.595521166142e-01
+ 1.080900000000e-05 6.596130958294e-01
+ 1.081000000000e-05 6.596740750447e-01
+ 1.081100000000e-05 6.597350542599e-01
+ 1.081200000000e-05 6.597960334751e-01
+ 1.081300000000e-05 6.598570126903e-01
+ 1.081400000000e-05 6.599179919055e-01
+ 1.081500000000e-05 6.599789711207e-01
+ 1.081600000000e-05 6.600399503359e-01
+ 1.081700000000e-05 6.601009295512e-01
+ 1.081800000000e-05 6.601619087664e-01
+ 1.081900000000e-05 6.602228879816e-01
+ 1.082000000000e-05 6.602838671968e-01
+ 1.082100000000e-05 6.603448464120e-01
+ 1.082200000000e-05 6.604058256272e-01
+ 1.082300000000e-05 6.604668048425e-01
+ 1.082400000000e-05 6.605277840577e-01
+ 1.082500000000e-05 6.605887632729e-01
+ 1.082600000000e-05 6.606497424881e-01
+ 1.082700000000e-05 6.607107217033e-01
+ 1.082800000000e-05 6.607717009185e-01
+ 1.082900000000e-05 6.608326801338e-01
+ 1.083000000000e-05 6.608936593490e-01
+ 1.083100000000e-05 6.609546385642e-01
+ 1.083200000000e-05 6.610156177794e-01
+ 1.083300000000e-05 6.610765969946e-01
+ 1.083400000000e-05 6.611375762098e-01
+ 1.083500000000e-05 6.611985554251e-01
+ 1.083600000000e-05 6.612595346403e-01
+ 1.083700000000e-05 6.613205138555e-01
+ 1.083800000000e-05 6.613814930707e-01
+ 1.083900000000e-05 6.614424722859e-01
+ 1.084000000000e-05 6.615034515011e-01
+ 1.084100000000e-05 6.615644307164e-01
+ 1.084200000000e-05 6.616254099316e-01
+ 1.084300000000e-05 6.616863891468e-01
+ 1.084400000000e-05 6.617473683620e-01
+ 1.084500000000e-05 6.618083475772e-01
+ 1.084600000000e-05 6.618693267924e-01
+ 1.084700000000e-05 6.619303060077e-01
+ 1.084800000000e-05 6.619912852229e-01
+ 1.084900000000e-05 6.620522644381e-01
+ 1.085000000000e-05 6.621132436533e-01
+ 1.085100000000e-05 6.621742228685e-01
+ 1.085200000000e-05 6.622352020837e-01
+ 1.085300000000e-05 6.622961812990e-01
+ 1.085400000000e-05 6.623571605142e-01
+ 1.085500000000e-05 6.624181397294e-01
+ 1.085600000000e-05 6.624791189446e-01
+ 1.085700000000e-05 6.625400981598e-01
+ 1.085800000000e-05 6.626010773750e-01
+ 1.085900000000e-05 6.626620565903e-01
+ 1.086000000000e-05 6.627230358055e-01
+ 1.086100000000e-05 6.627840150207e-01
+ 1.086200000000e-05 6.628449942359e-01
+ 1.086300000000e-05 6.629059734511e-01
+ 1.086400000000e-05 6.629669526663e-01
+ 1.086500000000e-05 6.630279318816e-01
+ 1.086600000000e-05 6.630889110968e-01
+ 1.086700000000e-05 6.631498903120e-01
+ 1.086800000000e-05 6.632108695272e-01
+ 1.086900000000e-05 6.632718487424e-01
+ 1.087000000000e-05 6.633328279576e-01
+ 1.087100000000e-05 6.633938071729e-01
+ 1.087200000000e-05 6.634547863881e-01
+ 1.087300000000e-05 6.635157656033e-01
+ 1.087400000000e-05 6.635767448185e-01
+ 1.087500000000e-05 6.636377240337e-01
+ 1.087600000000e-05 6.636987032489e-01
+ 1.087700000000e-05 6.637596824642e-01
+ 1.087800000000e-05 6.638206616794e-01
+ 1.087900000000e-05 6.638816408946e-01
+ 1.088000000000e-05 6.639426201098e-01
+ 1.088100000000e-05 6.640035993250e-01
+ 1.088200000000e-05 6.640645785402e-01
+ 1.088300000000e-05 6.641255577555e-01
+ 1.088400000000e-05 6.641865369707e-01
+ 1.088500000000e-05 6.642475161859e-01
+ 1.088600000000e-05 6.643084954011e-01
+ 1.088700000000e-05 6.643694746163e-01
+ 1.088800000000e-05 6.644304538315e-01
+ 1.088900000000e-05 6.644914330468e-01
+ 1.089000000000e-05 6.645524122620e-01
+ 1.089100000000e-05 6.646133914772e-01
+ 1.089200000000e-05 6.646743706924e-01
+ 1.089300000000e-05 6.647353499076e-01
+ 1.089400000000e-05 6.647963291228e-01
+ 1.089500000000e-05 6.648573083381e-01
+ 1.089600000000e-05 6.649182875533e-01
+ 1.089700000000e-05 6.649792667685e-01
+ 1.089800000000e-05 6.650402459837e-01
+ 1.089900000000e-05 6.651012251989e-01
+ 1.090000000000e-05 6.651622044141e-01
+ 1.090100000000e-05 6.652231836294e-01
+ 1.090200000000e-05 6.652841628446e-01
+ 1.090300000000e-05 6.653451420598e-01
+ 1.090400000000e-05 6.654061212750e-01
+ 1.090500000000e-05 6.654671004902e-01
+ 1.090600000000e-05 6.655280797054e-01
+ 1.090700000000e-05 6.655890589207e-01
+ 1.090800000000e-05 6.656500381359e-01
+ 1.090900000000e-05 6.657110173511e-01
+ 1.091000000000e-05 6.657719965663e-01
+ 1.091100000000e-05 6.658329757815e-01
+ 1.091200000000e-05 6.658939549967e-01
+ 1.091300000000e-05 6.659549342120e-01
+ 1.091400000000e-05 6.660159134272e-01
+ 1.091500000000e-05 6.660768926424e-01
+ 1.091600000000e-05 6.661378718576e-01
+ 1.091700000000e-05 6.661988510728e-01
+ 1.091800000000e-05 6.662598302880e-01
+ 1.091900000000e-05 6.663208095033e-01
+ 1.092000000000e-05 6.663817887185e-01
+ 1.092100000000e-05 6.664427679337e-01
+ 1.092200000000e-05 6.665037471489e-01
+ 1.092300000000e-05 6.665647263641e-01
+ 1.092400000000e-05 6.666257055793e-01
+ 1.092500000000e-05 6.666866847946e-01
+ 1.092600000000e-05 6.667476640098e-01
+ 1.092700000000e-05 6.668086432250e-01
+ 1.092800000000e-05 6.668696224402e-01
+ 1.092900000000e-05 6.669306016554e-01
+ 1.093000000000e-05 6.669915808706e-01
+ 1.093100000000e-05 6.670525600859e-01
+ 1.093200000000e-05 6.671135393011e-01
+ 1.093300000000e-05 6.671745185163e-01
+ 1.093400000000e-05 6.672354977315e-01
+ 1.093500000000e-05 6.672964769467e-01
+ 1.093600000000e-05 6.673574561619e-01
+ 1.093700000000e-05 6.674184353772e-01
+ 1.093800000000e-05 6.674794145924e-01
+ 1.093900000000e-05 6.675403938076e-01
+ 1.094000000000e-05 6.676013730228e-01
+ 1.094100000000e-05 6.676623522380e-01
+ 1.094200000000e-05 6.677233314532e-01
+ 1.094300000000e-05 6.677843106685e-01
+ 1.094400000000e-05 6.678452898837e-01
+ 1.094500000000e-05 6.679062690989e-01
+ 1.094600000000e-05 6.679672483141e-01
+ 1.094700000000e-05 6.680282275293e-01
+ 1.094800000000e-05 6.680892067445e-01
+ 1.094900000000e-05 6.681501859598e-01
+ 1.095000000000e-05 6.682111651750e-01
+ 1.095100000000e-05 6.682721443902e-01
+ 1.095200000000e-05 6.683331236054e-01
+ 1.095300000000e-05 6.683941028206e-01
+ 1.095400000000e-05 6.684550820358e-01
+ 1.095500000000e-05 6.685160612511e-01
+ 1.095600000000e-05 6.685770404663e-01
+ 1.095700000000e-05 6.686380196815e-01
+ 1.095800000000e-05 6.686989988967e-01
+ 1.095900000000e-05 6.687599781119e-01
+ 1.096000000000e-05 6.688209573271e-01
+ 1.096100000000e-05 6.688819365424e-01
+ 1.096200000000e-05 6.689429157576e-01
+ 1.096300000000e-05 6.690038949728e-01
+ 1.096400000000e-05 6.690648741880e-01
+ 1.096500000000e-05 6.691258534032e-01
+ 1.096600000000e-05 6.691868326184e-01
+ 1.096700000000e-05 6.692478118337e-01
+ 1.096800000000e-05 6.693087910489e-01
+ 1.096900000000e-05 6.693697702641e-01
+ 1.097000000000e-05 6.694307494793e-01
+ 1.097100000000e-05 6.694917286945e-01
+ 1.097200000000e-05 6.695527079097e-01
+ 1.097300000000e-05 6.696136871250e-01
+ 1.097400000000e-05 6.696746663402e-01
+ 1.097500000000e-05 6.697356455554e-01
+ 1.097600000000e-05 6.697966247706e-01
+ 1.097700000000e-05 6.698576039858e-01
+ 1.097800000000e-05 6.699185832010e-01
+ 1.097900000000e-05 6.699795624163e-01
+ 1.098000000000e-05 6.700405416315e-01
+ 1.098100000000e-05 6.701015208467e-01
+ 1.098200000000e-05 6.701625000619e-01
+ 1.098300000000e-05 6.702234792771e-01
+ 1.098400000000e-05 6.702844584923e-01
+ 1.098500000000e-05 6.703454377076e-01
+ 1.098600000000e-05 6.704064169228e-01
+ 1.098700000000e-05 6.704673961380e-01
+ 1.098800000000e-05 6.705283753532e-01
+ 1.098900000000e-05 6.705893545684e-01
+ 1.099000000000e-05 6.706503337836e-01
+ 1.099100000000e-05 6.707113129989e-01
+ 1.099200000000e-05 6.707722922141e-01
+ 1.099300000000e-05 6.708332714293e-01
+ 1.099400000000e-05 6.708942506445e-01
+ 1.099500000000e-05 6.709552298597e-01
+ 1.099600000000e-05 6.710162090749e-01
+ 1.099700000000e-05 6.710771882902e-01
+ 1.099800000000e-05 6.711381675054e-01
+ 1.099900000000e-05 6.711991467206e-01
+ 1.100000000000e-05 6.712601259358e-01
+ 1.100100000000e-05 6.713211051510e-01
+ 1.100200000000e-05 6.713820843662e-01
+ 1.100300000000e-05 6.714430635815e-01
+ 1.100400000000e-05 6.715040427967e-01
+ 1.100500000000e-05 6.715650220119e-01
+ 1.100600000000e-05 6.716260012271e-01
+ 1.100700000000e-05 6.716869804423e-01
+ 1.100800000000e-05 6.717479596575e-01
+ 1.100900000000e-05 6.718089388728e-01
+ 1.101000000000e-05 6.718699180880e-01
+ 1.101100000000e-05 6.719308973032e-01
+ 1.101200000000e-05 6.719918765184e-01
+ 1.101300000000e-05 6.720528557336e-01
+ 1.101400000000e-05 6.721138349488e-01
+ 1.101500000000e-05 6.721748141641e-01
+ 1.101600000000e-05 6.722357933793e-01
+ 1.101700000000e-05 6.722967725945e-01
+ 1.101800000000e-05 6.723577518097e-01
+ 1.101900000000e-05 6.724187310249e-01
+ 1.102000000000e-05 6.724797102401e-01
+ 1.102100000000e-05 6.725406894554e-01
+ 1.102200000000e-05 6.726016686706e-01
+ 1.102300000000e-05 6.726626478858e-01
+ 1.102400000000e-05 6.727236271010e-01
+ 1.102500000000e-05 6.727846063162e-01
+ 1.102600000000e-05 6.728455855314e-01
+ 1.102700000000e-05 6.729065647467e-01
+ 1.102800000000e-05 6.729675439619e-01
+ 1.102900000000e-05 6.730285231771e-01
+ 1.103000000000e-05 6.730895023923e-01
+ 1.103100000000e-05 6.731504816075e-01
+ 1.103200000000e-05 6.732114608227e-01
+ 1.103300000000e-05 6.732724400380e-01
+ 1.103400000000e-05 6.733334192532e-01
+ 1.103500000000e-05 6.733943984684e-01
+ 1.103600000000e-05 6.734553776836e-01
+ 1.103700000000e-05 6.735163568988e-01
+ 1.103800000000e-05 6.735773361140e-01
+ 1.103900000000e-05 6.736383153292e-01
+ 1.104000000000e-05 6.736992945445e-01
+ 1.104100000000e-05 6.737602737597e-01
+ 1.104200000000e-05 6.738212529749e-01
+ 1.104300000000e-05 6.738822321901e-01
+ 1.104400000000e-05 6.739432114053e-01
+ 1.104500000000e-05 6.740041906205e-01
+ 1.104600000000e-05 6.740651698358e-01
+ 1.104700000000e-05 6.741261490510e-01
+ 1.104800000000e-05 6.741871282662e-01
+ 1.104900000000e-05 6.742481074814e-01
+ 1.105000000000e-05 6.743090866966e-01
+ 1.105100000000e-05 6.743700659118e-01
+ 1.105200000000e-05 6.744310451271e-01
+ 1.105300000000e-05 6.744920243423e-01
+ 1.105400000000e-05 6.745530035575e-01
+ 1.105500000000e-05 6.746139827727e-01
+ 1.105600000000e-05 6.746749619879e-01
+ 1.105700000000e-05 6.747359412031e-01
+ 1.105800000000e-05 6.747969204184e-01
+ 1.105900000000e-05 6.748578996336e-01
+ 1.106000000000e-05 6.749188788488e-01
+ 1.106100000000e-05 6.749798580640e-01
+ 1.106200000000e-05 6.750408372792e-01
+ 1.106300000000e-05 6.751018164944e-01
+ 1.106400000000e-05 6.751627957097e-01
+ 1.106500000000e-05 6.752237749249e-01
+ 1.106600000000e-05 6.752847541401e-01
+ 1.106700000000e-05 6.753457333553e-01
+ 1.106800000000e-05 6.754067125705e-01
+ 1.106900000000e-05 6.754676917857e-01
+ 1.107000000000e-05 6.755286710010e-01
+ 1.107100000000e-05 6.755896502162e-01
+ 1.107200000000e-05 6.756506294314e-01
+ 1.107300000000e-05 6.757116086466e-01
+ 1.107400000000e-05 6.757725878618e-01
+ 1.107500000000e-05 6.758335670770e-01
+ 1.107600000000e-05 6.758945462923e-01
+ 1.107700000000e-05 6.759555255075e-01
+ 1.107800000000e-05 6.760165047227e-01
+ 1.107900000000e-05 6.760774839379e-01
+ 1.108000000000e-05 6.761384631531e-01
+ 1.108100000000e-05 6.761994423683e-01
+ 1.108200000000e-05 6.762604215836e-01
+ 1.108300000000e-05 6.763214007988e-01
+ 1.108400000000e-05 6.763823800140e-01
+ 1.108500000000e-05 6.764433592292e-01
+ 1.108600000000e-05 6.765043384444e-01
+ 1.108700000000e-05 6.765653176596e-01
+ 1.108800000000e-05 6.766262968749e-01
+ 1.108900000000e-05 6.766872760901e-01
+ 1.109000000000e-05 6.767482553053e-01
+ 1.109100000000e-05 6.768092345205e-01
+ 1.109200000000e-05 6.768702137357e-01
+ 1.109300000000e-05 6.769311929509e-01
+ 1.109400000000e-05 6.769921721662e-01
+ 1.109500000000e-05 6.770531513814e-01
+ 1.109600000000e-05 6.771141305966e-01
+ 1.109700000000e-05 6.771751098118e-01
+ 1.109800000000e-05 6.772360890270e-01
+ 1.109900000000e-05 6.772970682422e-01
+ 1.110000000000e-05 6.773580474575e-01
+ 1.110100000000e-05 6.774190266727e-01
+ 1.110200000000e-05 6.774800058879e-01
+ 1.110300000000e-05 6.775409851031e-01
+ 1.110400000000e-05 6.776019643183e-01
+ 1.110500000000e-05 6.776629435335e-01
+ 1.110600000000e-05 6.777239227488e-01
+ 1.110700000000e-05 6.777849019640e-01
+ 1.110800000000e-05 6.778458811792e-01
+ 1.110900000000e-05 6.779068603944e-01
+ 1.111000000000e-05 6.779678396096e-01
+ 1.111100000000e-05 6.780288188248e-01
+ 1.111200000000e-05 6.780897980401e-01
+ 1.111300000000e-05 6.781507772553e-01
+ 1.111400000000e-05 6.782117564705e-01
+ 1.111500000000e-05 6.782727356857e-01
+ 1.111600000000e-05 6.783337149009e-01
+ 1.111700000000e-05 6.783946941161e-01
+ 1.111800000000e-05 6.784556733314e-01
+ 1.111900000000e-05 6.785166525466e-01
+ 1.112000000000e-05 6.785776317618e-01
+ 1.112100000000e-05 6.786386109770e-01
+ 1.112200000000e-05 6.786995901922e-01
+ 1.112300000000e-05 6.787605694074e-01
+ 1.112400000000e-05 6.788215486227e-01
+ 1.112500000000e-05 6.788825278379e-01
+ 1.112600000000e-05 6.789435070531e-01
+ 1.112700000000e-05 6.790044862683e-01
+ 1.112800000000e-05 6.790654654835e-01
+ 1.112900000000e-05 6.791264446987e-01
+ 1.113000000000e-05 6.791874239140e-01
+ 1.113100000000e-05 6.792484031292e-01
+ 1.113200000000e-05 6.793093823444e-01
+ 1.113300000000e-05 6.793703615596e-01
+ 1.113400000000e-05 6.794313407748e-01
+ 1.113500000000e-05 6.794923199900e-01
+ 1.113600000000e-05 6.795532992053e-01
+ 1.113700000000e-05 6.796142784205e-01
+ 1.113800000000e-05 6.796752576357e-01
+ 1.113900000000e-05 6.797362368509e-01
+ 1.114000000000e-05 6.797972160661e-01
+ 1.114100000000e-05 6.798581952813e-01
+ 1.114200000000e-05 6.799191744966e-01
+ 1.114300000000e-05 6.799801537118e-01
+ 1.114400000000e-05 6.800411329270e-01
+ 1.114500000000e-05 6.801021121422e-01
+ 1.114600000000e-05 6.801630913574e-01
+ 1.114700000000e-05 6.802240705726e-01
+ 1.114800000000e-05 6.802850497879e-01
+ 1.114900000000e-05 6.803460290031e-01
+ 1.115000000000e-05 6.804070082183e-01
+ 1.115100000000e-05 6.804679874335e-01
+ 1.115200000000e-05 6.805289666487e-01
+ 1.115300000000e-05 6.805899458639e-01
+ 1.115400000000e-05 6.806509250792e-01
+ 1.115500000000e-05 6.807119042944e-01
+ 1.115600000000e-05 6.807728835096e-01
+ 1.115700000000e-05 6.808338627248e-01
+ 1.115800000000e-05 6.808948419400e-01
+ 1.115900000000e-05 6.809558211552e-01
+ 1.116000000000e-05 6.810168003705e-01
+ 1.116100000000e-05 6.810777795857e-01
+ 1.116200000000e-05 6.811387588009e-01
+ 1.116300000000e-05 6.811997380161e-01
+ 1.116400000000e-05 6.812607172313e-01
+ 1.116500000000e-05 6.813216964465e-01
+ 1.116600000000e-05 6.813826756618e-01
+ 1.116700000000e-05 6.814436548770e-01
+ 1.116800000000e-05 6.815046340922e-01
+ 1.116900000000e-05 6.815656133074e-01
+ 1.117000000000e-05 6.816265925226e-01
+ 1.117100000000e-05 6.816875717378e-01
+ 1.117200000000e-05 6.817485509531e-01
+ 1.117300000000e-05 6.818095301683e-01
+ 1.117400000000e-05 6.818705093835e-01
+ 1.117500000000e-05 6.819314885987e-01
+ 1.117600000000e-05 6.819924678139e-01
+ 1.117700000000e-05 6.820534470291e-01
+ 1.117800000000e-05 6.821144262444e-01
+ 1.117900000000e-05 6.821754054596e-01
+ 1.118000000000e-05 6.822363846748e-01
+ 1.118100000000e-05 6.822973638900e-01
+ 1.118200000000e-05 6.823583431052e-01
+ 1.118300000000e-05 6.824193223204e-01
+ 1.118400000000e-05 6.824803015357e-01
+ 1.118500000000e-05 6.825412807509e-01
+ 1.118600000000e-05 6.826022599661e-01
+ 1.118700000000e-05 6.826632391813e-01
+ 1.118800000000e-05 6.827242183965e-01
+ 1.118900000000e-05 6.827851976117e-01
+ 1.119000000000e-05 6.828461768270e-01
+ 1.119100000000e-05 6.829071560422e-01
+ 1.119200000000e-05 6.829681352574e-01
+ 1.119300000000e-05 6.830291144726e-01
+ 1.119400000000e-05 6.830900936878e-01
+ 1.119500000000e-05 6.831510729030e-01
+ 1.119600000000e-05 6.832120521183e-01
+ 1.119700000000e-05 6.832730313335e-01
+ 1.119800000000e-05 6.833340105487e-01
+ 1.119900000000e-05 6.833949897639e-01
+ 1.120000000000e-05 6.834559689791e-01
+ 1.120100000000e-05 6.835169481943e-01
+ 1.120200000000e-05 6.835779274096e-01
+ 1.120300000000e-05 6.836389066248e-01
+ 1.120400000000e-05 6.836998858400e-01
+ 1.120500000000e-05 6.837608650552e-01
+ 1.120600000000e-05 6.838218442704e-01
+ 1.120700000000e-05 6.838828234856e-01
+ 1.120800000000e-05 6.839438027009e-01
+ 1.120900000000e-05 6.840047819161e-01
+ 1.121000000000e-05 6.840657611313e-01
+ 1.121100000000e-05 6.841267403465e-01
+ 1.121200000000e-05 6.841877195617e-01
+ 1.121300000000e-05 6.842486987769e-01
+ 1.121400000000e-05 6.843096779922e-01
+ 1.121500000000e-05 6.843706572074e-01
+ 1.121600000000e-05 6.844316364226e-01
+ 1.121700000000e-05 6.844926156378e-01
+ 1.121800000000e-05 6.845535948530e-01
+ 1.121900000000e-05 6.846145740682e-01
+ 1.122000000000e-05 6.846755532835e-01
+ 1.122100000000e-05 6.847365324987e-01
+ 1.122200000000e-05 6.847975117139e-01
+ 1.122300000000e-05 6.848584909291e-01
+ 1.122400000000e-05 6.849194701443e-01
+ 1.122500000000e-05 6.849804493595e-01
+ 1.122600000000e-05 6.850414285748e-01
+ 1.122700000000e-05 6.851024077900e-01
+ 1.122800000000e-05 6.851633870052e-01
+ 1.122900000000e-05 6.852243662204e-01
+ 1.123000000000e-05 6.852853454356e-01
+ 1.123100000000e-05 6.853463246508e-01
+ 1.123200000000e-05 6.854073038661e-01
+ 1.123300000000e-05 6.854682830813e-01
+ 1.123400000000e-05 6.855292622965e-01
+ 1.123500000000e-05 6.855902415117e-01
+ 1.123600000000e-05 6.856512207269e-01
+ 1.123700000000e-05 6.857121999421e-01
+ 1.123800000000e-05 6.857731791574e-01
+ 1.123900000000e-05 6.858341583726e-01
+ 1.124000000000e-05 6.858951375878e-01
+ 1.124100000000e-05 6.859561168030e-01
+ 1.124200000000e-05 6.860170960182e-01
+ 1.124300000000e-05 6.860780752334e-01
+ 1.124400000000e-05 6.861390544487e-01
+ 1.124500000000e-05 6.862000336639e-01
+ 1.124600000000e-05 6.862610128791e-01
+ 1.124700000000e-05 6.863219920943e-01
+ 1.124800000000e-05 6.863829713095e-01
+ 1.124900000000e-05 6.864439505247e-01
+ 1.125000000000e-05 6.865049297400e-01
+ 1.125100000000e-05 6.865659089552e-01
+ 1.125200000000e-05 6.866268881704e-01
+ 1.125300000000e-05 6.866878673856e-01
+ 1.125400000000e-05 6.867488466008e-01
+ 1.125500000000e-05 6.868098258160e-01
+ 1.125600000000e-05 6.868708050313e-01
+ 1.125700000000e-05 6.869317842465e-01
+ 1.125800000000e-05 6.869927634617e-01
+ 1.125900000000e-05 6.870537426769e-01
+ 1.126000000000e-05 6.871147218921e-01
+ 1.126100000000e-05 6.871757011073e-01
+ 1.126200000000e-05 6.872366803226e-01
+ 1.126300000000e-05 6.872976595378e-01
+ 1.126400000000e-05 6.873586387530e-01
+ 1.126500000000e-05 6.874196179682e-01
+ 1.126600000000e-05 6.874805971834e-01
+ 1.126700000000e-05 6.875415763986e-01
+ 1.126800000000e-05 6.876025556138e-01
+ 1.126900000000e-05 6.876635348291e-01
+ 1.127000000000e-05 6.877245140443e-01
+ 1.127100000000e-05 6.877854932595e-01
+ 1.127200000000e-05 6.878464724747e-01
+ 1.127300000000e-05 6.879074516899e-01
+ 1.127400000000e-05 6.879684309051e-01
+ 1.127500000000e-05 6.880294101204e-01
+ 1.127600000000e-05 6.880903893356e-01
+ 1.127700000000e-05 6.881513685508e-01
+ 1.127800000000e-05 6.882123477660e-01
+ 1.127900000000e-05 6.882733269812e-01
+ 1.128000000000e-05 6.883343061964e-01
+ 1.128100000000e-05 6.883952854117e-01
+ 1.128200000000e-05 6.884562646269e-01
+ 1.128300000000e-05 6.885172438421e-01
+ 1.128400000000e-05 6.885782230573e-01
+ 1.128500000000e-05 6.886392022725e-01
+ 1.128600000000e-05 6.887001814877e-01
+ 1.128700000000e-05 6.887611607030e-01
+ 1.128800000000e-05 6.888221399182e-01
+ 1.128900000000e-05 6.888831191334e-01
+ 1.129000000000e-05 6.889440983486e-01
+ 1.129100000000e-05 6.890050775638e-01
+ 1.129200000000e-05 6.890660567790e-01
+ 1.129300000000e-05 6.891270359943e-01
+ 1.129400000000e-05 6.891880152095e-01
+ 1.129500000000e-05 6.892489944247e-01
+ 1.129600000000e-05 6.893099736399e-01
+ 1.129700000000e-05 6.893709528551e-01
+ 1.129800000000e-05 6.894319320703e-01
+ 1.129900000000e-05 6.894929112856e-01
+ 1.130000000000e-05 6.895538905008e-01
+ 1.130100000000e-05 6.896148697160e-01
+ 1.130200000000e-05 6.896758489312e-01
+ 1.130300000000e-05 6.897368281464e-01
+ 1.130400000000e-05 6.897978073616e-01
+ 1.130500000000e-05 6.898587865769e-01
+ 1.130600000000e-05 6.899197657921e-01
+ 1.130700000000e-05 6.899807450073e-01
+ 1.130800000000e-05 6.900417242225e-01
+ 1.130900000000e-05 6.901027034377e-01
+ 1.131000000000e-05 6.901636826529e-01
+ 1.131100000000e-05 6.902246618682e-01
+ 1.131200000000e-05 6.902856410834e-01
+ 1.131300000000e-05 6.903466202986e-01
+ 1.131400000000e-05 6.904075995138e-01
+ 1.131500000000e-05 6.904685787290e-01
+ 1.131600000000e-05 6.905295579442e-01
+ 1.131700000000e-05 6.905905371595e-01
+ 1.131800000000e-05 6.906515163747e-01
+ 1.131900000000e-05 6.907124955899e-01
+ 1.132000000000e-05 6.907734748051e-01
+ 1.132100000000e-05 6.908344540203e-01
+ 1.132200000000e-05 6.908954332355e-01
+ 1.132300000000e-05 6.909564124508e-01
+ 1.132400000000e-05 6.910173916660e-01
+ 1.132500000000e-05 6.910783708812e-01
+ 1.132600000000e-05 6.911393500964e-01
+ 1.132700000000e-05 6.912003293116e-01
+ 1.132800000000e-05 6.912613085268e-01
+ 1.132900000000e-05 6.913222877421e-01
+ 1.133000000000e-05 6.913832669573e-01
+ 1.133100000000e-05 6.914442461725e-01
+ 1.133200000000e-05 6.915052253877e-01
+ 1.133300000000e-05 6.915662046029e-01
+ 1.133400000000e-05 6.916271838181e-01
+ 1.133500000000e-05 6.916881630334e-01
+ 1.133600000000e-05 6.917491422486e-01
+ 1.133700000000e-05 6.918101214638e-01
+ 1.133800000000e-05 6.918711006790e-01
+ 1.133900000000e-05 6.919320798942e-01
+ 1.134000000000e-05 6.919930591094e-01
+ 1.134100000000e-05 6.920540383247e-01
+ 1.134200000000e-05 6.921150175399e-01
+ 1.134300000000e-05 6.921759967551e-01
+ 1.134400000000e-05 6.922369759703e-01
+ 1.134500000000e-05 6.922979551855e-01
+ 1.134600000000e-05 6.923589344007e-01
+ 1.134700000000e-05 6.924199136160e-01
+ 1.134800000000e-05 6.924808928312e-01
+ 1.134900000000e-05 6.925418720464e-01
+ 1.135000000000e-05 6.926028512616e-01
+ 1.135100000000e-05 6.926638304768e-01
+ 1.135200000000e-05 6.927248096920e-01
+ 1.135300000000e-05 6.927857889073e-01
+ 1.135400000000e-05 6.928467681225e-01
+ 1.135500000000e-05 6.929077473377e-01
+ 1.135600000000e-05 6.929687265529e-01
+ 1.135700000000e-05 6.930297057681e-01
+ 1.135800000000e-05 6.930906849833e-01
+ 1.135900000000e-05 6.931516641986e-01
+ 1.136000000000e-05 6.932126434138e-01
+ 1.136100000000e-05 6.932736226290e-01
+ 1.136200000000e-05 6.933346018442e-01
+ 1.136300000000e-05 6.933955810594e-01
+ 1.136400000000e-05 6.934565602746e-01
+ 1.136500000000e-05 6.935175394899e-01
+ 1.136600000000e-05 6.935785187051e-01
+ 1.136700000000e-05 6.936394979203e-01
+ 1.136800000000e-05 6.937004771355e-01
+ 1.136900000000e-05 6.937614563507e-01
+ 1.137000000000e-05 6.938224355659e-01
+ 1.137100000000e-05 6.938834147812e-01
+ 1.137200000000e-05 6.939443939964e-01
+ 1.137300000000e-05 6.940053732116e-01
+ 1.137400000000e-05 6.940663524268e-01
+ 1.137500000000e-05 6.941273316420e-01
+ 1.137600000000e-05 6.941883108572e-01
+ 1.137700000000e-05 6.942492900725e-01
+ 1.137800000000e-05 6.943102692877e-01
+ 1.137900000000e-05 6.943712485029e-01
+ 1.138000000000e-05 6.944322277181e-01
+ 1.138100000000e-05 6.944932069333e-01
+ 1.138200000000e-05 6.945541861485e-01
+ 1.138300000000e-05 6.946151653638e-01
+ 1.138400000000e-05 6.946761445790e-01
+ 1.138500000000e-05 6.947371237942e-01
+ 1.138600000000e-05 6.947981030094e-01
+ 1.138700000000e-05 6.948590822246e-01
+ 1.138800000000e-05 6.949200614398e-01
+ 1.138900000000e-05 6.949810406551e-01
+ 1.139000000000e-05 6.950420198703e-01
+ 1.139100000000e-05 6.951029990855e-01
+ 1.139200000000e-05 6.951639783007e-01
+ 1.139300000000e-05 6.952249575159e-01
+ 1.139400000000e-05 6.952859367311e-01
+ 1.139500000000e-05 6.953469159464e-01
+ 1.139600000000e-05 6.954078951616e-01
+ 1.139700000000e-05 6.954688743768e-01
+ 1.139800000000e-05 6.955298535920e-01
+ 1.139900000000e-05 6.955908328072e-01
+ 1.140000000000e-05 6.956518120224e-01
+ 1.140100000000e-05 6.957127912377e-01
+ 1.140200000000e-05 6.957737704529e-01
+ 1.140300000000e-05 6.958347496681e-01
+ 1.140400000000e-05 6.958957288833e-01
+ 1.140500000000e-05 6.959567080985e-01
+ 1.140600000000e-05 6.960176873137e-01
+ 1.140700000000e-05 6.960786665290e-01
+ 1.140800000000e-05 6.961396457442e-01
+ 1.140900000000e-05 6.962006249594e-01
+ 1.141000000000e-05 6.962616041746e-01
+ 1.141100000000e-05 6.963225833898e-01
+ 1.141200000000e-05 6.963835626050e-01
+ 1.141300000000e-05 6.964445418203e-01
+ 1.141400000000e-05 6.965055210355e-01
+ 1.141500000000e-05 6.965665002507e-01
+ 1.141600000000e-05 6.966274794659e-01
+ 1.141700000000e-05 6.966884586811e-01
+ 1.141800000000e-05 6.967494378963e-01
+ 1.141900000000e-05 6.968104171116e-01
+ 1.142000000000e-05 6.968713963268e-01
+ 1.142100000000e-05 6.969323755420e-01
+ 1.142200000000e-05 6.969933547572e-01
+ 1.142300000000e-05 6.970543339724e-01
+ 1.142400000000e-05 6.971153131876e-01
+ 1.142500000000e-05 6.971762924029e-01
+ 1.142600000000e-05 6.972372716181e-01
+ 1.142700000000e-05 6.972982508333e-01
+ 1.142800000000e-05 6.973592300485e-01
+ 1.142900000000e-05 6.974202092637e-01
+ 1.143000000000e-05 6.974811884789e-01
+ 1.143100000000e-05 6.975421676942e-01
+ 1.143200000000e-05 6.976031469094e-01
+ 1.143300000000e-05 6.976641261246e-01
+ 1.143400000000e-05 6.977251053398e-01
+ 1.143500000000e-05 6.977860845550e-01
+ 1.143600000000e-05 6.978470637702e-01
+ 1.143700000000e-05 6.979080429855e-01
+ 1.143800000000e-05 6.979690222007e-01
+ 1.143900000000e-05 6.980300014159e-01
+ 1.144000000000e-05 6.980909806311e-01
+ 1.144100000000e-05 6.981519598463e-01
+ 1.144200000000e-05 6.982129390615e-01
+ 1.144300000000e-05 6.982739182768e-01
+ 1.144400000000e-05 6.983348974920e-01
+ 1.144500000000e-05 6.983958767072e-01
+ 1.144600000000e-05 6.984568559224e-01
+ 1.144700000000e-05 6.985178351376e-01
+ 1.144800000000e-05 6.985788143528e-01
+ 1.144900000000e-05 6.986397935681e-01
+ 1.145000000000e-05 6.987007727833e-01
+ 1.145100000000e-05 6.987617519985e-01
+ 1.145200000000e-05 6.988227312137e-01
+ 1.145300000000e-05 6.988837104289e-01
+ 1.145400000000e-05 6.989446896441e-01
+ 1.145500000000e-05 6.990056688594e-01
+ 1.145600000000e-05 6.990666480746e-01
+ 1.145700000000e-05 6.991276272898e-01
+ 1.145800000000e-05 6.991886065050e-01
+ 1.145900000000e-05 6.992495857202e-01
+ 1.146000000000e-05 6.993105649354e-01
+ 1.146100000000e-05 6.993715441507e-01
+ 1.146200000000e-05 6.994325233659e-01
+ 1.146300000000e-05 6.994935025811e-01
+ 1.146400000000e-05 6.995544817963e-01
+ 1.146500000000e-05 6.996154610115e-01
+ 1.146600000000e-05 6.996764402267e-01
+ 1.146700000000e-05 6.997374194420e-01
+ 1.146800000000e-05 6.997983986572e-01
+ 1.146900000000e-05 6.998593778724e-01
+ 1.147000000000e-05 6.999203570876e-01
+ 1.147100000000e-05 6.999813363028e-01
+ 1.147200000000e-05 7.000423155180e-01
+ 1.147300000000e-05 7.001032947333e-01
+ 1.147400000000e-05 7.001642739485e-01
+ 1.147500000000e-05 7.002252531637e-01
+ 1.147600000000e-05 7.002862323789e-01
+ 1.147700000000e-05 7.003472115941e-01
+ 1.147800000000e-05 7.004081908093e-01
+ 1.147900000000e-05 7.004691700246e-01
+ 1.148000000000e-05 7.005301492398e-01
+ 1.148100000000e-05 7.005911284550e-01
+ 1.148200000000e-05 7.006521076702e-01
+ 1.148300000000e-05 7.007130868854e-01
+ 1.148400000000e-05 7.007740661006e-01
+ 1.148500000000e-05 7.008350453159e-01
+ 1.148600000000e-05 7.008960245311e-01
+ 1.148700000000e-05 7.009570037463e-01
+ 1.148800000000e-05 7.010179829615e-01
+ 1.148900000000e-05 7.010789621767e-01
+ 1.149000000000e-05 7.011399413919e-01
+ 1.149100000000e-05 7.012009206072e-01
+ 1.149200000000e-05 7.012618998224e-01
+ 1.149300000000e-05 7.013228790376e-01
+ 1.149400000000e-05 7.013838582528e-01
+ 1.149500000000e-05 7.014448374680e-01
+ 1.149600000000e-05 7.015058166832e-01
+ 1.149700000000e-05 7.015667958984e-01
+ 1.149800000000e-05 7.016277751137e-01
+ 1.149900000000e-05 7.016887543289e-01
+ 1.150000000000e-05 7.017497335441e-01
+ 1.150100000000e-05 7.018107127593e-01
+ 1.150200000000e-05 7.018716919745e-01
+ 1.150300000000e-05 7.019326711897e-01
+ 1.150400000000e-05 7.019936504050e-01
+ 1.150500000000e-05 7.020546296202e-01
+ 1.150600000000e-05 7.021156088354e-01
+ 1.150700000000e-05 7.021765880506e-01
+ 1.150800000000e-05 7.022375672658e-01
+ 1.150900000000e-05 7.022985464810e-01
+ 1.151000000000e-05 7.023595256963e-01
+ 1.151100000000e-05 7.024205049115e-01
+ 1.151200000000e-05 7.024814841267e-01
+ 1.151300000000e-05 7.025424633419e-01
+ 1.151400000000e-05 7.026034425571e-01
+ 1.151500000000e-05 7.026644217723e-01
+ 1.151600000000e-05 7.027254009876e-01
+ 1.151700000000e-05 7.027863802028e-01
+ 1.151800000000e-05 7.028473594180e-01
+ 1.151900000000e-05 7.029083386332e-01
+ 1.152000000000e-05 7.029693178484e-01
+ 1.152100000000e-05 7.030302970636e-01
+ 1.152200000000e-05 7.030912762789e-01
+ 1.152300000000e-05 7.031522554941e-01
+ 1.152400000000e-05 7.032132347093e-01
+ 1.152500000000e-05 7.032742139245e-01
+ 1.152600000000e-05 7.033351931397e-01
+ 1.152700000000e-05 7.033961723549e-01
+ 1.152800000000e-05 7.034571515702e-01
+ 1.152900000000e-05 7.035181307854e-01
+ 1.153000000000e-05 7.035791100006e-01
+ 1.153100000000e-05 7.036400892158e-01
+ 1.153200000000e-05 7.037010684310e-01
+ 1.153300000000e-05 7.037620476462e-01
+ 1.153400000000e-05 7.038230268615e-01
+ 1.153500000000e-05 7.038840060767e-01
+ 1.153600000000e-05 7.039449852919e-01
+ 1.153700000000e-05 7.040059645071e-01
+ 1.153800000000e-05 7.040669437223e-01
+ 1.153900000000e-05 7.041279229375e-01
+ 1.154000000000e-05 7.041889021528e-01
+ 1.154100000000e-05 7.042498813680e-01
+ 1.154200000000e-05 7.043108605832e-01
+ 1.154300000000e-05 7.043718397984e-01
+ 1.154400000000e-05 7.044328190136e-01
+ 1.154500000000e-05 7.044937982288e-01
+ 1.154600000000e-05 7.045547774441e-01
+ 1.154700000000e-05 7.046157566593e-01
+ 1.154800000000e-05 7.046767358745e-01
+ 1.154900000000e-05 7.047377150897e-01
+ 1.155000000000e-05 7.047986943049e-01
+ 1.155100000000e-05 7.048596735201e-01
+ 1.155200000000e-05 7.049206527354e-01
+ 1.155300000000e-05 7.049816319506e-01
+ 1.155400000000e-05 7.050426111658e-01
+ 1.155500000000e-05 7.051035903810e-01
+ 1.155600000000e-05 7.051645695962e-01
+ 1.155700000000e-05 7.052255488114e-01
+ 1.155800000000e-05 7.052865280267e-01
+ 1.155900000000e-05 7.053475072419e-01
+ 1.156000000000e-05 7.054084864571e-01
+ 1.156100000000e-05 7.054694656723e-01
+ 1.156200000000e-05 7.055304448875e-01
+ 1.156300000000e-05 7.055914241027e-01
+ 1.156400000000e-05 7.056524033180e-01
+ 1.156500000000e-05 7.057133825332e-01
+ 1.156600000000e-05 7.057743617484e-01
+ 1.156700000000e-05 7.058353409636e-01
+ 1.156800000000e-05 7.058963201788e-01
+ 1.156900000000e-05 7.059572993940e-01
+ 1.157000000000e-05 7.060182786093e-01
+ 1.157100000000e-05 7.060792578245e-01
+ 1.157200000000e-05 7.061402370397e-01
+ 1.157300000000e-05 7.062012162549e-01
+ 1.157400000000e-05 7.062621954701e-01
+ 1.157500000000e-05 7.063231746853e-01
+ 1.157600000000e-05 7.063841539006e-01
+ 1.157700000000e-05 7.064451331158e-01
+ 1.157800000000e-05 7.065061123310e-01
+ 1.157900000000e-05 7.065670915462e-01
+ 1.158000000000e-05 7.066280707614e-01
+ 1.158100000000e-05 7.066890499766e-01
+ 1.158200000000e-05 7.067500291919e-01
+ 1.158300000000e-05 7.068110084071e-01
+ 1.158400000000e-05 7.068719876223e-01
+ 1.158500000000e-05 7.069329668375e-01
+ 1.158600000000e-05 7.069939460527e-01
+ 1.158700000000e-05 7.070549252679e-01
+ 1.158800000000e-05 7.071159044832e-01
+ 1.158900000000e-05 7.071768836984e-01
+ 1.159000000000e-05 7.072378629136e-01
+ 1.159100000000e-05 7.072988421288e-01
+ 1.159200000000e-05 7.073598213440e-01
+ 1.159300000000e-05 7.074208005592e-01
+ 1.159400000000e-05 7.074817797745e-01
+ 1.159500000000e-05 7.075427589897e-01
+ 1.159600000000e-05 7.076037382049e-01
+ 1.159700000000e-05 7.076647174201e-01
+ 1.159800000000e-05 7.077256966353e-01
+ 1.159900000000e-05 7.077866758505e-01
+ 1.160000000000e-05 7.078476550658e-01
+ 1.160100000000e-05 7.079086342810e-01
+ 1.160200000000e-05 7.079696134962e-01
+ 1.160300000000e-05 7.080305927114e-01
+ 1.160400000000e-05 7.080915719266e-01
+ 1.160500000000e-05 7.081525511418e-01
+ 1.160600000000e-05 7.082135303571e-01
+ 1.160700000000e-05 7.082745095723e-01
+ 1.160800000000e-05 7.083354887875e-01
+ 1.160900000000e-05 7.083964680027e-01
+ 1.161000000000e-05 7.084574472179e-01
+ 1.161100000000e-05 7.085184264331e-01
+ 1.161200000000e-05 7.085794056484e-01
+ 1.161300000000e-05 7.086403848636e-01
+ 1.161400000000e-05 7.087013640788e-01
+ 1.161500000000e-05 7.087623432940e-01
+ 1.161600000000e-05 7.088233225092e-01
+ 1.161700000000e-05 7.088843017244e-01
+ 1.161800000000e-05 7.089452809397e-01
+ 1.161900000000e-05 7.090062601549e-01
+ 1.162000000000e-05 7.090672393701e-01
+ 1.162100000000e-05 7.091282185853e-01
+ 1.162200000000e-05 7.091891978005e-01
+ 1.162300000000e-05 7.092501770157e-01
+ 1.162400000000e-05 7.093111562310e-01
+ 1.162500000000e-05 7.093721354462e-01
+ 1.162600000000e-05 7.094331146614e-01
+ 1.162700000000e-05 7.094940938766e-01
+ 1.162800000000e-05 7.095550730918e-01
+ 1.162900000000e-05 7.096160523070e-01
+ 1.163000000000e-05 7.096770315223e-01
+ 1.163100000000e-05 7.097380107375e-01
+ 1.163200000000e-05 7.097989899527e-01
+ 1.163300000000e-05 7.098599691679e-01
+ 1.163400000000e-05 7.099209483831e-01
+ 1.163500000000e-05 7.099819275983e-01
+ 1.163600000000e-05 7.100429068136e-01
+ 1.163700000000e-05 7.101038860288e-01
+ 1.163800000000e-05 7.101648652440e-01
+ 1.163900000000e-05 7.102258444592e-01
+ 1.164000000000e-05 7.102868236744e-01
+ 1.164100000000e-05 7.103478028896e-01
+ 1.164200000000e-05 7.104087821049e-01
+ 1.164300000000e-05 7.104697613201e-01
+ 1.164400000000e-05 7.105307405353e-01
+ 1.164500000000e-05 7.105917197505e-01
+ 1.164600000000e-05 7.106526989657e-01
+ 1.164700000000e-05 7.107136781809e-01
+ 1.164800000000e-05 7.107746573962e-01
+ 1.164900000000e-05 7.108356366114e-01
+ 1.165000000000e-05 7.108966158266e-01
+ 1.165100000000e-05 7.109575950418e-01
+ 1.165200000000e-05 7.110185742570e-01
+ 1.165300000000e-05 7.110795534722e-01
+ 1.165400000000e-05 7.111405326875e-01
+ 1.165500000000e-05 7.112015119027e-01
+ 1.165600000000e-05 7.112624911179e-01
+ 1.165700000000e-05 7.113234703331e-01
+ 1.165800000000e-05 7.113844495483e-01
+ 1.165900000000e-05 7.114454287635e-01
+ 1.166000000000e-05 7.115064079788e-01
+ 1.166100000000e-05 7.115673871940e-01
+ 1.166200000000e-05 7.116283664092e-01
+ 1.166300000000e-05 7.116893456244e-01
+ 1.166400000000e-05 7.117503248396e-01
+ 1.166500000000e-05 7.118113040548e-01
+ 1.166600000000e-05 7.118722832701e-01
+ 1.166700000000e-05 7.119332624853e-01
+ 1.166800000000e-05 7.119942417005e-01
+ 1.166900000000e-05 7.120552209157e-01
+ 1.167000000000e-05 7.121162001309e-01
+ 1.167100000000e-05 7.121771793461e-01
+ 1.167200000000e-05 7.122381585614e-01
+ 1.167300000000e-05 7.122991377766e-01
+ 1.167400000000e-05 7.123601169918e-01
+ 1.167500000000e-05 7.124210962070e-01
+ 1.167600000000e-05 7.124820754222e-01
+ 1.167700000000e-05 7.125430546374e-01
+ 1.167800000000e-05 7.126040338527e-01
+ 1.167900000000e-05 7.126650130679e-01
+ 1.168000000000e-05 7.127259922831e-01
+ 1.168100000000e-05 7.127869714983e-01
+ 1.168200000000e-05 7.128479507135e-01
+ 1.168300000000e-05 7.129089299287e-01
+ 1.168400000000e-05 7.129699091440e-01
+ 1.168500000000e-05 7.130308883592e-01
+ 1.168600000000e-05 7.130918675744e-01
+ 1.168700000000e-05 7.131528467896e-01
+ 1.168800000000e-05 7.132138260048e-01
+ 1.168900000000e-05 7.132748052200e-01
+ 1.169000000000e-05 7.133357844353e-01
+ 1.169100000000e-05 7.133967636505e-01
+ 1.169200000000e-05 7.134577428657e-01
+ 1.169300000000e-05 7.135187220809e-01
+ 1.169400000000e-05 7.135797012961e-01
+ 1.169500000000e-05 7.136406805113e-01
+ 1.169600000000e-05 7.137016597266e-01
+ 1.169700000000e-05 7.137626389418e-01
+ 1.169800000000e-05 7.138236181570e-01
+ 1.169900000000e-05 7.138845973722e-01
+ 1.170000000000e-05 7.139455765874e-01
+ 1.170100000000e-05 7.140065558026e-01
+ 1.170200000000e-05 7.140675350179e-01
+ 1.170300000000e-05 7.141285142331e-01
+ 1.170400000000e-05 7.141894934483e-01
+ 1.170500000000e-05 7.142504726635e-01
+ 1.170600000000e-05 7.143114518787e-01
+ 1.170700000000e-05 7.143724310939e-01
+ 1.170800000000e-05 7.144334103092e-01
+ 1.170900000000e-05 7.144943895244e-01
+ 1.171000000000e-05 7.145553687396e-01
+ 1.171100000000e-05 7.146163479548e-01
+ 1.171200000000e-05 7.146773271700e-01
+ 1.171300000000e-05 7.147383063852e-01
+ 1.171400000000e-05 7.147992856005e-01
+ 1.171500000000e-05 7.148602648157e-01
+ 1.171600000000e-05 7.149212440309e-01
+ 1.171700000000e-05 7.149822232461e-01
+ 1.171800000000e-05 7.150432024613e-01
+ 1.171900000000e-05 7.151041816765e-01
+ 1.172000000000e-05 7.151651608918e-01
+ 1.172100000000e-05 7.152261401070e-01
+ 1.172200000000e-05 7.152871193222e-01
+ 1.172300000000e-05 7.153480985374e-01
+ 1.172400000000e-05 7.154090777526e-01
+ 1.172500000000e-05 7.154700569678e-01
+ 1.172600000000e-05 7.155310361830e-01
+ 1.172700000000e-05 7.155920153983e-01
+ 1.172800000000e-05 7.156529946135e-01
+ 1.172900000000e-05 7.157139738287e-01
+ 1.173000000000e-05 7.157749530439e-01
+ 1.173100000000e-05 7.158359322591e-01
+ 1.173200000000e-05 7.158969114743e-01
+ 1.173300000000e-05 7.159578906896e-01
+ 1.173400000000e-05 7.160188699048e-01
+ 1.173500000000e-05 7.160798491200e-01
+ 1.173600000000e-05 7.161408283352e-01
+ 1.173700000000e-05 7.162018075504e-01
+ 1.173800000000e-05 7.162627867656e-01
+ 1.173900000000e-05 7.163237659809e-01
+ 1.174000000000e-05 7.163847451961e-01
+ 1.174100000000e-05 7.164457244113e-01
+ 1.174200000000e-05 7.165067036265e-01
+ 1.174300000000e-05 7.165676828417e-01
+ 1.174400000000e-05 7.166286620569e-01
+ 1.174500000000e-05 7.166896412722e-01
+ 1.174600000000e-05 7.167506204874e-01
+ 1.174700000000e-05 7.168115997026e-01
+ 1.174800000000e-05 7.168725789178e-01
+ 1.174900000000e-05 7.169335581330e-01
+ 1.175000000000e-05 7.169945373482e-01
+ 1.175100000000e-05 7.170555165635e-01
+ 1.175200000000e-05 7.171164957787e-01
+ 1.175300000000e-05 7.171774749939e-01
+ 1.175400000000e-05 7.172384542091e-01
+ 1.175500000000e-05 7.172994334243e-01
+ 1.175600000000e-05 7.173604126395e-01
+ 1.175700000000e-05 7.174213918548e-01
+ 1.175800000000e-05 7.174823710700e-01
+ 1.175900000000e-05 7.175433502852e-01
+ 1.176000000000e-05 7.176043295004e-01
+ 1.176100000000e-05 7.176653087156e-01
+ 1.176200000000e-05 7.177262879308e-01
+ 1.176300000000e-05 7.177872671461e-01
+ 1.176400000000e-05 7.178482463613e-01
+ 1.176500000000e-05 7.179092255765e-01
+ 1.176600000000e-05 7.179702047917e-01
+ 1.176700000000e-05 7.180311840069e-01
+ 1.176800000000e-05 7.180921632221e-01
+ 1.176900000000e-05 7.181531424374e-01
+ 1.177000000000e-05 7.182141216526e-01
+ 1.177100000000e-05 7.182751008678e-01
+ 1.177200000000e-05 7.183360800830e-01
+ 1.177300000000e-05 7.183970592982e-01
+ 1.177400000000e-05 7.184580385134e-01
+ 1.177500000000e-05 7.185190177287e-01
+ 1.177600000000e-05 7.185799969439e-01
+ 1.177700000000e-05 7.186409761591e-01
+ 1.177800000000e-05 7.187019553743e-01
+ 1.177900000000e-05 7.187629345895e-01
+ 1.178000000000e-05 7.188239138047e-01
+ 1.178100000000e-05 7.188848930200e-01
+ 1.178200000000e-05 7.189458722352e-01
+ 1.178300000000e-05 7.190068514504e-01
+ 1.178400000000e-05 7.190678306656e-01
+ 1.178500000000e-05 7.191288098808e-01
+ 1.178600000000e-05 7.191897890960e-01
+ 1.178700000000e-05 7.192507683113e-01
+ 1.178800000000e-05 7.193117475265e-01
+ 1.178900000000e-05 7.193727267417e-01
+ 1.179000000000e-05 7.194337059569e-01
+ 1.179100000000e-05 7.194946851721e-01
+ 1.179200000000e-05 7.195556643873e-01
+ 1.179300000000e-05 7.196166436026e-01
+ 1.179400000000e-05 7.196776228178e-01
+ 1.179500000000e-05 7.197386020330e-01
+ 1.179600000000e-05 7.197995812482e-01
+ 1.179700000000e-05 7.198605604634e-01
+ 1.179800000000e-05 7.199215396786e-01
+ 1.179900000000e-05 7.199825188939e-01
+ 1.180000000000e-05 7.200434981091e-01
+ 1.180100000000e-05 7.201044773243e-01
+ 1.180200000000e-05 7.201654565395e-01
+ 1.180300000000e-05 7.202264357547e-01
+ 1.180400000000e-05 7.202874149699e-01
+ 1.180500000000e-05 7.203483941852e-01
+ 1.180600000000e-05 7.204093734004e-01
+ 1.180700000000e-05 7.204703526156e-01
+ 1.180800000000e-05 7.205313318308e-01
+ 1.180900000000e-05 7.205923110460e-01
+ 1.181000000000e-05 7.206532902612e-01
+ 1.181100000000e-05 7.207142694765e-01
+ 1.181200000000e-05 7.207752486917e-01
+ 1.181300000000e-05 7.208362279069e-01
+ 1.181400000000e-05 7.208972071221e-01
+ 1.181500000000e-05 7.209581863373e-01
+ 1.181600000000e-05 7.210191655525e-01
+ 1.181700000000e-05 7.210801447678e-01
+ 1.181800000000e-05 7.211411239830e-01
+ 1.181900000000e-05 7.212021031982e-01
+ 1.182000000000e-05 7.212630824134e-01
+ 1.182100000000e-05 7.213240616286e-01
+ 1.182200000000e-05 7.213850408438e-01
+ 1.182300000000e-05 7.214460200591e-01
+ 1.182400000000e-05 7.215069992743e-01
+ 1.182500000000e-05 7.215679784895e-01
+ 1.182600000000e-05 7.216289577047e-01
+ 1.182700000000e-05 7.216899369199e-01
+ 1.182800000000e-05 7.217509161351e-01
+ 1.182900000000e-05 7.218118953504e-01
+ 1.183000000000e-05 7.218728745656e-01
+ 1.183100000000e-05 7.219338537808e-01
+ 1.183200000000e-05 7.219948329960e-01
+ 1.183300000000e-05 7.220558122112e-01
+ 1.183400000000e-05 7.221167914264e-01
+ 1.183500000000e-05 7.221777706417e-01
+ 1.183600000000e-05 7.222387498569e-01
+ 1.183700000000e-05 7.222997290721e-01
+ 1.183800000000e-05 7.223607082873e-01
+ 1.183900000000e-05 7.224216875025e-01
+ 1.184000000000e-05 7.224826667177e-01
+ 1.184100000000e-05 7.225436459330e-01
+ 1.184200000000e-05 7.226046251482e-01
+ 1.184300000000e-05 7.226656043634e-01
+ 1.184400000000e-05 7.227265835786e-01
+ 1.184500000000e-05 7.227875627938e-01
+ 1.184600000000e-05 7.228485420090e-01
+ 1.184700000000e-05 7.229095212243e-01
+ 1.184800000000e-05 7.229705004395e-01
+ 1.184900000000e-05 7.230314796547e-01
+ 1.185000000000e-05 7.230924588699e-01
+ 1.185100000000e-05 7.231534380851e-01
+ 1.185200000000e-05 7.232144173003e-01
+ 1.185300000000e-05 7.232753965156e-01
+ 1.185400000000e-05 7.233363757308e-01
+ 1.185500000000e-05 7.233973549460e-01
+ 1.185600000000e-05 7.234583341612e-01
+ 1.185700000000e-05 7.235193133764e-01
+ 1.185800000000e-05 7.235802925916e-01
+ 1.185900000000e-05 7.236412718069e-01
+ 1.186000000000e-05 7.237022510221e-01
+ 1.186100000000e-05 7.237632302373e-01
+ 1.186200000000e-05 7.238242094525e-01
+ 1.186300000000e-05 7.238851886677e-01
+ 1.186400000000e-05 7.239461678829e-01
+ 1.186500000000e-05 7.240071470982e-01
+ 1.186600000000e-05 7.240681263134e-01
+ 1.186700000000e-05 7.241291055286e-01
+ 1.186800000000e-05 7.241900847438e-01
+ 1.186900000000e-05 7.242510639590e-01
+ 1.187000000000e-05 7.243120431742e-01
+ 1.187100000000e-05 7.243730223895e-01
+ 1.187200000000e-05 7.244340016047e-01
+ 1.187300000000e-05 7.244949808199e-01
+ 1.187400000000e-05 7.245559600351e-01
+ 1.187500000000e-05 7.246169392503e-01
+ 1.187600000000e-05 7.246779184655e-01
+ 1.187700000000e-05 7.247388976808e-01
+ 1.187800000000e-05 7.247998768960e-01
+ 1.187900000000e-05 7.248608561112e-01
+ 1.188000000000e-05 7.249218353264e-01
+ 1.188100000000e-05 7.249828145416e-01
+ 1.188200000000e-05 7.250437937568e-01
+ 1.188300000000e-05 7.251047729721e-01
+ 1.188400000000e-05 7.251657521873e-01
+ 1.188500000000e-05 7.252267314025e-01
+ 1.188600000000e-05 7.252877106177e-01
+ 1.188700000000e-05 7.253486898329e-01
+ 1.188800000000e-05 7.254096690481e-01
+ 1.188900000000e-05 7.254706482634e-01
+ 1.189000000000e-05 7.255316274786e-01
+ 1.189100000000e-05 7.255926066938e-01
+ 1.189200000000e-05 7.256535859090e-01
+ 1.189300000000e-05 7.257145651242e-01
+ 1.189400000000e-05 7.257755443394e-01
+ 1.189500000000e-05 7.258365235547e-01
+ 1.189600000000e-05 7.258975027699e-01
+ 1.189700000000e-05 7.259584819851e-01
+ 1.189800000000e-05 7.260194612003e-01
+ 1.189900000000e-05 7.260804404155e-01
+ 1.190000000000e-05 7.261414196307e-01
+ 1.190100000000e-05 7.262023988460e-01
+ 1.190200000000e-05 7.262633780612e-01
+ 1.190300000000e-05 7.263243572764e-01
+ 1.190400000000e-05 7.263853364916e-01
+ 1.190500000000e-05 7.264463157068e-01
+ 1.190600000000e-05 7.265072949220e-01
+ 1.190700000000e-05 7.265682741373e-01
+ 1.190800000000e-05 7.266292533525e-01
+ 1.190900000000e-05 7.266902325677e-01
+ 1.191000000000e-05 7.267512117829e-01
+ 1.191100000000e-05 7.268121909981e-01
+ 1.191200000000e-05 7.268731702133e-01
+ 1.191300000000e-05 7.269341494286e-01
+ 1.191400000000e-05 7.269951286438e-01
+ 1.191500000000e-05 7.270561078590e-01
+ 1.191600000000e-05 7.271170870742e-01
+ 1.191700000000e-05 7.271780662894e-01
+ 1.191800000000e-05 7.272390455046e-01
+ 1.191900000000e-05 7.273000247199e-01
+ 1.192000000000e-05 7.273610039351e-01
+ 1.192100000000e-05 7.274219831503e-01
+ 1.192200000000e-05 7.274829623655e-01
+ 1.192300000000e-05 7.275439415807e-01
+ 1.192400000000e-05 7.276049207959e-01
+ 1.192500000000e-05 7.276659000112e-01
+ 1.192600000000e-05 7.277268792264e-01
+ 1.192700000000e-05 7.277878584416e-01
+ 1.192800000000e-05 7.278488376568e-01
+ 1.192900000000e-05 7.279098168720e-01
+ 1.193000000000e-05 7.279707960872e-01
+ 1.193100000000e-05 7.280317753025e-01
+ 1.193200000000e-05 7.280927545177e-01
+ 1.193300000000e-05 7.281537337329e-01
+ 1.193400000000e-05 7.282147129481e-01
+ 1.193500000000e-05 7.282756921633e-01
+ 1.193600000000e-05 7.283366713785e-01
+ 1.193700000000e-05 7.283976505938e-01
+ 1.193800000000e-05 7.284586298090e-01
+ 1.193900000000e-05 7.285196090242e-01
+ 1.194000000000e-05 7.285805882394e-01
+ 1.194100000000e-05 7.286415674546e-01
+ 1.194200000000e-05 7.287025466698e-01
+ 1.194300000000e-05 7.287635258851e-01
+ 1.194400000000e-05 7.288245051003e-01
+ 1.194500000000e-05 7.288854843155e-01
+ 1.194600000000e-05 7.289464635307e-01
+ 1.194700000000e-05 7.290074427459e-01
+ 1.194800000000e-05 7.290684219611e-01
+ 1.194900000000e-05 7.291294011763e-01
+ 1.195000000000e-05 7.291903803916e-01
+ 1.195100000000e-05 7.292513596068e-01
+ 1.195200000000e-05 7.293123388220e-01
+ 1.195300000000e-05 7.293733180372e-01
+ 1.195400000000e-05 7.294342972524e-01
+ 1.195500000000e-05 7.294952764676e-01
+ 1.195600000000e-05 7.295562556829e-01
+ 1.195700000000e-05 7.296172348981e-01
+ 1.195800000000e-05 7.296782141133e-01
+ 1.195900000000e-05 7.297391933285e-01
+ 1.196000000000e-05 7.298001725437e-01
+ 1.196100000000e-05 7.298611517589e-01
+ 1.196200000000e-05 7.299221309742e-01
+ 1.196300000000e-05 7.299831101894e-01
+ 1.196400000000e-05 7.300440894046e-01
+ 1.196500000000e-05 7.301050686198e-01
+ 1.196600000000e-05 7.301660478350e-01
+ 1.196700000000e-05 7.302270270502e-01
+ 1.196800000000e-05 7.302880062655e-01
+ 1.196900000000e-05 7.303489854807e-01
+ 1.197000000000e-05 7.304099646959e-01
+ 1.197100000000e-05 7.304709439111e-01
+ 1.197200000000e-05 7.305319231263e-01
+ 1.197300000000e-05 7.305929023415e-01
+ 1.197400000000e-05 7.306538815568e-01
+ 1.197500000000e-05 7.307148607720e-01
+ 1.197600000000e-05 7.307758399872e-01
+ 1.197700000000e-05 7.308368192024e-01
+ 1.197800000000e-05 7.308977984176e-01
+ 1.197900000000e-05 7.309587776328e-01
+ 1.198000000000e-05 7.310197568481e-01
+ 1.198100000000e-05 7.310807360633e-01
+ 1.198200000000e-05 7.311417152785e-01
+ 1.198300000000e-05 7.312026944937e-01
+ 1.198400000000e-05 7.312636737089e-01
+ 1.198500000000e-05 7.313246529241e-01
+ 1.198600000000e-05 7.313856321394e-01
+ 1.198700000000e-05 7.314466113546e-01
+ 1.198800000000e-05 7.315075905698e-01
+ 1.198900000000e-05 7.315685697850e-01
+ 1.199000000000e-05 7.316295490002e-01
+ 1.199100000000e-05 7.316905282154e-01
+ 1.199200000000e-05 7.317515074307e-01
+ 1.199300000000e-05 7.318124866459e-01
+ 1.199400000000e-05 7.318734658611e-01
+ 1.199500000000e-05 7.319344450763e-01
+ 1.199600000000e-05 7.319954242915e-01
+ 1.199700000000e-05 7.320564035067e-01
+ 1.199800000000e-05 7.321173827220e-01
+ 1.199900000000e-05 7.321783619372e-01
+ 1.200000000000e-05 7.322393411524e-01
+ 1.200100000000e-05 7.323003203676e-01
+ 1.200200000000e-05 7.323612995828e-01
+ 1.200300000000e-05 7.324222787980e-01
+ 1.200400000000e-05 7.324832580133e-01
+ 1.200500000000e-05 7.325442372285e-01
+ 1.200600000000e-05 7.326052164437e-01
+ 1.200700000000e-05 7.326661956589e-01
+ 1.200800000000e-05 7.327271748741e-01
+ 1.200900000000e-05 7.327881540893e-01
+ 1.201000000000e-05 7.328491333046e-01
+ 1.201100000000e-05 7.329101125198e-01
+ 1.201200000000e-05 7.329710917350e-01
+ 1.201300000000e-05 7.330320709502e-01
+ 1.201400000000e-05 7.330930501654e-01
+ 1.201500000000e-05 7.331540293806e-01
+ 1.201600000000e-05 7.332150085959e-01
+ 1.201700000000e-05 7.332759878111e-01
+ 1.201800000000e-05 7.333369670263e-01
+ 1.201900000000e-05 7.333979462415e-01
+ 1.202000000000e-05 7.334589254567e-01
+ 1.202100000000e-05 7.335199046719e-01
+ 1.202200000000e-05 7.335808838872e-01
+ 1.202300000000e-05 7.336418631024e-01
+ 1.202400000000e-05 7.337028423176e-01
+ 1.202500000000e-05 7.337638215328e-01
+ 1.202600000000e-05 7.338248007480e-01
+ 1.202700000000e-05 7.338857799632e-01
+ 1.202800000000e-05 7.339467591785e-01
+ 1.202900000000e-05 7.340077383937e-01
+ 1.203000000000e-05 7.340687176089e-01
+ 1.203100000000e-05 7.341296968241e-01
+ 1.203200000000e-05 7.341906760393e-01
+ 1.203300000000e-05 7.342516552545e-01
+ 1.203400000000e-05 7.343126344698e-01
+ 1.203500000000e-05 7.343736136850e-01
+ 1.203600000000e-05 7.344345929002e-01
+ 1.203700000000e-05 7.344955721154e-01
+ 1.203800000000e-05 7.345565513306e-01
+ 1.203900000000e-05 7.346175305458e-01
+ 1.204000000000e-05 7.346785097611e-01
+ 1.204100000000e-05 7.347394889763e-01
+ 1.204200000000e-05 7.348004681915e-01
+ 1.204300000000e-05 7.348614474067e-01
+ 1.204400000000e-05 7.349224266219e-01
+ 1.204500000000e-05 7.349834058371e-01
+ 1.204600000000e-05 7.350443850524e-01
+ 1.204700000000e-05 7.351053642676e-01
+ 1.204800000000e-05 7.351663434828e-01
+ 1.204900000000e-05 7.352273226980e-01
+ 1.205000000000e-05 7.352883019132e-01
+ 1.205100000000e-05 7.353492811284e-01
+ 1.205200000000e-05 7.354102603437e-01
+ 1.205300000000e-05 7.354712395589e-01
+ 1.205400000000e-05 7.355322187741e-01
+ 1.205500000000e-05 7.355931979893e-01
+ 1.205600000000e-05 7.356541772045e-01
+ 1.205700000000e-05 7.357151564197e-01
+ 1.205800000000e-05 7.357761356350e-01
+ 1.205900000000e-05 7.358371148502e-01
+ 1.206000000000e-05 7.358980940654e-01
+ 1.206100000000e-05 7.359590732806e-01
+ 1.206200000000e-05 7.360200524958e-01
+ 1.206300000000e-05 7.360810317110e-01
+ 1.206400000000e-05 7.361420109263e-01
+ 1.206500000000e-05 7.362029901415e-01
+ 1.206600000000e-05 7.362639693567e-01
+ 1.206700000000e-05 7.363249485719e-01
+ 1.206800000000e-05 7.363859277871e-01
+ 1.206900000000e-05 7.364469070023e-01
+ 1.207000000000e-05 7.365078862176e-01
+ 1.207100000000e-05 7.365688654328e-01
+ 1.207200000000e-05 7.366298446480e-01
+ 1.207300000000e-05 7.366908238632e-01
+ 1.207400000000e-05 7.367518030784e-01
+ 1.207500000000e-05 7.368127822936e-01
+ 1.207600000000e-05 7.368737615089e-01
+ 1.207700000000e-05 7.369347407241e-01
+ 1.207800000000e-05 7.369957199393e-01
+ 1.207900000000e-05 7.370566991545e-01
+ 1.208000000000e-05 7.371176783697e-01
+ 1.208100000000e-05 7.371786575849e-01
+ 1.208200000000e-05 7.372396368002e-01
+ 1.208300000000e-05 7.373006160154e-01
+ 1.208400000000e-05 7.373615952306e-01
+ 1.208500000000e-05 7.374225744458e-01
+ 1.208600000000e-05 7.374835536610e-01
+ 1.208700000000e-05 7.375445328762e-01
+ 1.208800000000e-05 7.376055120915e-01
+ 1.208900000000e-05 7.376664913067e-01
+ 1.209000000000e-05 7.377274705219e-01
+ 1.209100000000e-05 7.377884497371e-01
+ 1.209200000000e-05 7.378494289523e-01
+ 1.209300000000e-05 7.379104081675e-01
+ 1.209400000000e-05 7.379713873828e-01
+ 1.209500000000e-05 7.380323665980e-01
+ 1.209600000000e-05 7.380933458132e-01
+ 1.209700000000e-05 7.381543250284e-01
+ 1.209800000000e-05 7.382153042436e-01
+ 1.209900000000e-05 7.382762834588e-01
+ 1.210000000000e-05 7.383372626741e-01
+ 1.210100000000e-05 7.383982418893e-01
+ 1.210200000000e-05 7.384592211045e-01
+ 1.210300000000e-05 7.385202003197e-01
+ 1.210400000000e-05 7.385811795349e-01
+ 1.210500000000e-05 7.386421587501e-01
+ 1.210600000000e-05 7.387031379654e-01
+ 1.210700000000e-05 7.387641171806e-01
+ 1.210800000000e-05 7.388250963958e-01
+ 1.210900000000e-05 7.388860756110e-01
+ 1.211000000000e-05 7.389470548262e-01
+ 1.211100000000e-05 7.390080340414e-01
+ 1.211200000000e-05 7.390690132567e-01
+ 1.211300000000e-05 7.391299924719e-01
+ 1.211400000000e-05 7.391909716871e-01
+ 1.211500000000e-05 7.392519509023e-01
+ 1.211600000000e-05 7.393129301175e-01
+ 1.211700000000e-05 7.393739093327e-01
+ 1.211800000000e-05 7.394348885480e-01
+ 1.211900000000e-05 7.394958677632e-01
+ 1.212000000000e-05 7.395568469784e-01
+ 1.212100000000e-05 7.396178261936e-01
+ 1.212200000000e-05 7.396788054088e-01
+ 1.212300000000e-05 7.397397846240e-01
+ 1.212400000000e-05 7.398007638393e-01
+ 1.212500000000e-05 7.398617430545e-01
+ 1.212600000000e-05 7.399227222697e-01
+ 1.212700000000e-05 7.399837014849e-01
+ 1.212800000000e-05 7.400446807001e-01
+ 1.212900000000e-05 7.401056599153e-01
+ 1.213000000000e-05 7.401666391306e-01
+ 1.213100000000e-05 7.402276183458e-01
+ 1.213200000000e-05 7.402885975610e-01
+ 1.213300000000e-05 7.403495767762e-01
+ 1.213400000000e-05 7.404105559914e-01
+ 1.213500000000e-05 7.404715352066e-01
+ 1.213600000000e-05 7.405325144219e-01
+ 1.213700000000e-05 7.405934936371e-01
+ 1.213800000000e-05 7.406544728523e-01
+ 1.213900000000e-05 7.407154520675e-01
+ 1.214000000000e-05 7.407764312827e-01
+ 1.214100000000e-05 7.408374104979e-01
+ 1.214200000000e-05 7.408983897132e-01
+ 1.214300000000e-05 7.409593689284e-01
+ 1.214400000000e-05 7.410203481436e-01
+ 1.214500000000e-05 7.410813273588e-01
+ 1.214600000000e-05 7.411423065740e-01
+ 1.214700000000e-05 7.412032857892e-01
+ 1.214800000000e-05 7.412642650045e-01
+ 1.214900000000e-05 7.413252442197e-01
+ 1.215000000000e-05 7.413862234349e-01
+ 1.215100000000e-05 7.414472026501e-01
+ 1.215200000000e-05 7.415081818653e-01
+ 1.215300000000e-05 7.415691610805e-01
+ 1.215400000000e-05 7.416301402958e-01
+ 1.215500000000e-05 7.416911195110e-01
+ 1.215600000000e-05 7.417520987262e-01
+ 1.215700000000e-05 7.418130779414e-01
+ 1.215800000000e-05 7.418740571566e-01
+ 1.215900000000e-05 7.419350363718e-01
+ 1.216000000000e-05 7.419960155871e-01
+ 1.216100000000e-05 7.420569948023e-01
+ 1.216200000000e-05 7.421179740175e-01
+ 1.216300000000e-05 7.421789532327e-01
+ 1.216400000000e-05 7.422399324479e-01
+ 1.216500000000e-05 7.423009116631e-01
+ 1.216600000000e-05 7.423618908784e-01
+ 1.216700000000e-05 7.424228700936e-01
+ 1.216800000000e-05 7.424838493088e-01
+ 1.216900000000e-05 7.425448285240e-01
+ 1.217000000000e-05 7.426058077392e-01
+ 1.217100000000e-05 7.426667869544e-01
+ 1.217200000000e-05 7.427277661697e-01
+ 1.217300000000e-05 7.427887453849e-01
+ 1.217400000000e-05 7.428497246001e-01
+ 1.217500000000e-05 7.429107038153e-01
+ 1.217600000000e-05 7.429716830305e-01
+ 1.217700000000e-05 7.430326622457e-01
+ 1.217800000000e-05 7.430936414609e-01
+ 1.217900000000e-05 7.431546206762e-01
+ 1.218000000000e-05 7.432155998914e-01
+ 1.218100000000e-05 7.432765791066e-01
+ 1.218200000000e-05 7.433375583218e-01
+ 1.218300000000e-05 7.433985375370e-01
+ 1.218400000000e-05 7.434595167522e-01
+ 1.218500000000e-05 7.435204959675e-01
+ 1.218600000000e-05 7.435814751827e-01
+ 1.218700000000e-05 7.436424543979e-01
+ 1.218800000000e-05 7.437034336131e-01
+ 1.218900000000e-05 7.437644128283e-01
+ 1.219000000000e-05 7.438253920435e-01
+ 1.219100000000e-05 7.438863712588e-01
+ 1.219200000000e-05 7.439473504740e-01
+ 1.219300000000e-05 7.440083296892e-01
+ 1.219400000000e-05 7.440693089044e-01
+ 1.219500000000e-05 7.441302881196e-01
+ 1.219600000000e-05 7.441912673348e-01
+ 1.219700000000e-05 7.442522465501e-01
+ 1.219800000000e-05 7.443132257653e-01
+ 1.219900000000e-05 7.443742049805e-01
+ 1.220000000000e-05 7.444351841957e-01
+ 1.220100000000e-05 7.444961634109e-01
+ 1.220200000000e-05 7.445571426261e-01
+ 1.220300000000e-05 7.446181218414e-01
+ 1.220400000000e-05 7.446791010566e-01
+ 1.220500000000e-05 7.447400802718e-01
+ 1.220600000000e-05 7.448010594870e-01
+ 1.220700000000e-05 7.448620387022e-01
+ 1.220800000000e-05 7.449230179174e-01
+ 1.220900000000e-05 7.449839971327e-01
+ 1.221000000000e-05 7.450449763479e-01
+ 1.221100000000e-05 7.451059555631e-01
+ 1.221200000000e-05 7.451669347783e-01
+ 1.221300000000e-05 7.452279139935e-01
+ 1.221400000000e-05 7.452888932087e-01
+ 1.221500000000e-05 7.453498724240e-01
+ 1.221600000000e-05 7.454108516392e-01
+ 1.221700000000e-05 7.454718308544e-01
+ 1.221800000000e-05 7.455328100696e-01
+ 1.221900000000e-05 7.455937892848e-01
+ 1.222000000000e-05 7.456547685000e-01
+ 1.222100000000e-05 7.457157477153e-01
+ 1.222200000000e-05 7.457767269305e-01
+ 1.222300000000e-05 7.458377061457e-01
+ 1.222400000000e-05 7.458986853609e-01
+ 1.222500000000e-05 7.459596645761e-01
+ 1.222600000000e-05 7.460206437913e-01
+ 1.222700000000e-05 7.460816230066e-01
+ 1.222800000000e-05 7.461426022218e-01
+ 1.222900000000e-05 7.462035814370e-01
+ 1.223000000000e-05 7.462645606522e-01
+ 1.223100000000e-05 7.463255398674e-01
+ 1.223200000000e-05 7.463865190826e-01
+ 1.223300000000e-05 7.464474982979e-01
+ 1.223400000000e-05 7.465084775131e-01
+ 1.223500000000e-05 7.465694567283e-01
+ 1.223600000000e-05 7.466304359435e-01
+ 1.223700000000e-05 7.466914151587e-01
+ 1.223800000000e-05 7.467523943739e-01
+ 1.223900000000e-05 7.468133735892e-01
+ 1.224000000000e-05 7.468743528044e-01
+ 1.224100000000e-05 7.469353320196e-01
+ 1.224200000000e-05 7.469963112348e-01
+ 1.224300000000e-05 7.470572904500e-01
+ 1.224400000000e-05 7.471182696652e-01
+ 1.224500000000e-05 7.471792488805e-01
+ 1.224600000000e-05 7.472402280957e-01
+ 1.224700000000e-05 7.473012073109e-01
+ 1.224800000000e-05 7.473621865261e-01
+ 1.224900000000e-05 7.474231657413e-01
+ 1.225000000000e-05 7.474841449565e-01
+ 1.225100000000e-05 7.475451241718e-01
+ 1.225200000000e-05 7.476061033870e-01
+ 1.225300000000e-05 7.476670826022e-01
+ 1.225400000000e-05 7.477280618174e-01
+ 1.225500000000e-05 7.477890410326e-01
+ 1.225600000000e-05 7.478500202478e-01
+ 1.225700000000e-05 7.479109994631e-01
+ 1.225800000000e-05 7.479719786783e-01
+ 1.225900000000e-05 7.480329578935e-01
+ 1.226000000000e-05 7.480939371087e-01
+ 1.226100000000e-05 7.481549163239e-01
+ 1.226200000000e-05 7.482158955391e-01
+ 1.226300000000e-05 7.482768747544e-01
+ 1.226400000000e-05 7.483378539696e-01
+ 1.226500000000e-05 7.483988331848e-01
+ 1.226600000000e-05 7.484598124000e-01
+ 1.226700000000e-05 7.485207916152e-01
+ 1.226800000000e-05 7.485817708304e-01
+ 1.226900000000e-05 7.486427500457e-01
+ 1.227000000000e-05 7.487037292609e-01
+ 1.227100000000e-05 7.487647084761e-01
+ 1.227200000000e-05 7.488256876913e-01
+ 1.227300000000e-05 7.488866669065e-01
+ 1.227400000000e-05 7.489476461217e-01
+ 1.227500000000e-05 7.490086253370e-01
+ 1.227600000000e-05 7.490696045522e-01
+ 1.227700000000e-05 7.491305837674e-01
+ 1.227800000000e-05 7.491915629826e-01
+ 1.227900000000e-05 7.492525421978e-01
+ 1.228000000000e-05 7.493135214130e-01
+ 1.228100000000e-05 7.493745006283e-01
+ 1.228200000000e-05 7.494354798435e-01
+ 1.228300000000e-05 7.494964590587e-01
+ 1.228400000000e-05 7.495574382739e-01
+ 1.228500000000e-05 7.496184174891e-01
+ 1.228600000000e-05 7.496793967043e-01
+ 1.228700000000e-05 7.497403759196e-01
+ 1.228800000000e-05 7.498013551348e-01
+ 1.228900000000e-05 7.498623343500e-01
+ 1.229000000000e-05 7.499233135652e-01
+ 1.229100000000e-05 7.499842927804e-01
+ 1.229200000000e-05 7.500452719956e-01
+ 1.229300000000e-05 7.501062512109e-01
+ 1.229400000000e-05 7.501672304261e-01
+ 1.229500000000e-05 7.502282096413e-01
+ 1.229600000000e-05 7.502891888565e-01
+ 1.229700000000e-05 7.503501680717e-01
+ 1.229800000000e-05 7.504111472869e-01
+ 1.229900000000e-05 7.504721265022e-01
+ 1.230000000000e-05 7.505331057174e-01
+ 1.230100000000e-05 7.505940849326e-01
+ 1.230200000000e-05 7.506550641478e-01
+ 1.230300000000e-05 7.507160433630e-01
+ 1.230400000000e-05 7.507770225782e-01
+ 1.230500000000e-05 7.508380017935e-01
+ 1.230600000000e-05 7.508989810087e-01
+ 1.230700000000e-05 7.509599602239e-01
+ 1.230800000000e-05 7.510209394391e-01
+ 1.230900000000e-05 7.510819186543e-01
+ 1.231000000000e-05 7.511428978695e-01
+ 1.231100000000e-05 7.512038770848e-01
+ 1.231200000000e-05 7.512648563000e-01
+ 1.231300000000e-05 7.513258355152e-01
+ 1.231400000000e-05 7.513868147304e-01
+ 1.231500000000e-05 7.514477939456e-01
+ 1.231600000000e-05 7.515087731608e-01
+ 1.231700000000e-05 7.515697523761e-01
+ 1.231800000000e-05 7.516307315913e-01
+ 1.231900000000e-05 7.516917108065e-01
+ 1.232000000000e-05 7.517526900217e-01
+ 1.232100000000e-05 7.518136692369e-01
+ 1.232200000000e-05 7.518746484521e-01
+ 1.232300000000e-05 7.519356276674e-01
+ 1.232400000000e-05 7.519966068826e-01
+ 1.232500000000e-05 7.520575860978e-01
+ 1.232600000000e-05 7.521185653130e-01
+ 1.232700000000e-05 7.521795445282e-01
+ 1.232800000000e-05 7.522405237434e-01
+ 1.232900000000e-05 7.523015029587e-01
+ 1.233000000000e-05 7.523624821739e-01
+ 1.233100000000e-05 7.524234613891e-01
+ 1.233200000000e-05 7.524844406043e-01
+ 1.233300000000e-05 7.525454198195e-01
+ 1.233400000000e-05 7.526063990347e-01
+ 1.233500000000e-05 7.526673782500e-01
+ 1.233600000000e-05 7.527283574652e-01
+ 1.233700000000e-05 7.527893366804e-01
+ 1.233800000000e-05 7.528503158956e-01
+ 1.233900000000e-05 7.529112951108e-01
+ 1.234000000000e-05 7.529722743260e-01
+ 1.234100000000e-05 7.530332535413e-01
+ 1.234200000000e-05 7.530942327565e-01
+ 1.234300000000e-05 7.531552119717e-01
+ 1.234400000000e-05 7.532161911869e-01
+ 1.234500000000e-05 7.532771704021e-01
+ 1.234600000000e-05 7.533381496173e-01
+ 1.234700000000e-05 7.533991288326e-01
+ 1.234800000000e-05 7.534601080478e-01
+ 1.234900000000e-05 7.535210872630e-01
+ 1.235000000000e-05 7.535820664782e-01
+ 1.235100000000e-05 7.536430456934e-01
+ 1.235200000000e-05 7.537040249086e-01
+ 1.235300000000e-05 7.537650041239e-01
+ 1.235400000000e-05 7.538259833391e-01
+ 1.235500000000e-05 7.538869625543e-01
+ 1.235600000000e-05 7.539479417695e-01
+ 1.235700000000e-05 7.540089209847e-01
+ 1.235800000000e-05 7.540699001999e-01
+ 1.235900000000e-05 7.541308794152e-01
+ 1.236000000000e-05 7.541918586304e-01
+ 1.236100000000e-05 7.542528378456e-01
+ 1.236200000000e-05 7.543138170608e-01
+ 1.236300000000e-05 7.543747962760e-01
+ 1.236400000000e-05 7.544357754912e-01
+ 1.236500000000e-05 7.544967547065e-01
+ 1.236600000000e-05 7.545577339217e-01
+ 1.236700000000e-05 7.546187131369e-01
+ 1.236800000000e-05 7.546796923521e-01
+ 1.236900000000e-05 7.547406715673e-01
+ 1.237000000000e-05 7.548016507825e-01
+ 1.237100000000e-05 7.548626299978e-01
+ 1.237200000000e-05 7.549236092130e-01
+ 1.237300000000e-05 7.549845884282e-01
+ 1.237400000000e-05 7.550455676434e-01
+ 1.237500000000e-05 7.551065468586e-01
+ 1.237600000000e-05 7.551675260738e-01
+ 1.237700000000e-05 7.552285052891e-01
+ 1.237800000000e-05 7.552894845043e-01
+ 1.237900000000e-05 7.553504637195e-01
+ 1.238000000000e-05 7.554114429347e-01
+ 1.238100000000e-05 7.554724221499e-01
+ 1.238200000000e-05 7.555334013651e-01
+ 1.238300000000e-05 7.555943805804e-01
+ 1.238400000000e-05 7.556553597956e-01
+ 1.238500000000e-05 7.557163390108e-01
+ 1.238600000000e-05 7.557773182260e-01
+ 1.238700000000e-05 7.558382974412e-01
+ 1.238800000000e-05 7.558992766564e-01
+ 1.238900000000e-05 7.559602558717e-01
+ 1.239000000000e-05 7.560212350869e-01
+ 1.239100000000e-05 7.560822143021e-01
+ 1.239200000000e-05 7.561431935173e-01
+ 1.239300000000e-05 7.562041727325e-01
+ 1.239400000000e-05 7.562651519477e-01
+ 1.239500000000e-05 7.563261311630e-01
+ 1.239600000000e-05 7.563871103782e-01
+ 1.239700000000e-05 7.564480895934e-01
+ 1.239800000000e-05 7.565090688086e-01
+ 1.239900000000e-05 7.565700480238e-01
+ 1.240000000000e-05 7.566310272390e-01
+ 1.240100000000e-05 7.566920064543e-01
+ 1.240200000000e-05 7.567529856695e-01
+ 1.240300000000e-05 7.568139648847e-01
+ 1.240400000000e-05 7.568749440999e-01
+ 1.240500000000e-05 7.569359233151e-01
+ 1.240600000000e-05 7.569969025303e-01
+ 1.240700000000e-05 7.570578817455e-01
+ 1.240800000000e-05 7.571188609608e-01
+ 1.240900000000e-05 7.571798401760e-01
+ 1.241000000000e-05 7.572408193912e-01
+ 1.241100000000e-05 7.573017986064e-01
+ 1.241200000000e-05 7.573627778216e-01
+ 1.241300000000e-05 7.574237570368e-01
+ 1.241400000000e-05 7.574847362521e-01
+ 1.241500000000e-05 7.575457154673e-01
+ 1.241600000000e-05 7.576066946825e-01
+ 1.241700000000e-05 7.576676738977e-01
+ 1.241800000000e-05 7.577286531129e-01
+ 1.241900000000e-05 7.577896323281e-01
+ 1.242000000000e-05 7.578506115434e-01
+ 1.242100000000e-05 7.579115907586e-01
+ 1.242200000000e-05 7.579725699738e-01
+ 1.242300000000e-05 7.580335491890e-01
+ 1.242400000000e-05 7.580945284042e-01
+ 1.242500000000e-05 7.581555076194e-01
+ 1.242600000000e-05 7.582164868347e-01
+ 1.242700000000e-05 7.582774660499e-01
+ 1.242800000000e-05 7.583384452651e-01
+ 1.242900000000e-05 7.583994244803e-01
+ 1.243000000000e-05 7.584604036955e-01
+ 1.243100000000e-05 7.585213829107e-01
+ 1.243200000000e-05 7.585823621260e-01
+ 1.243300000000e-05 7.586433413412e-01
+ 1.243400000000e-05 7.587043205564e-01
+ 1.243500000000e-05 7.587652997716e-01
+ 1.243600000000e-05 7.588262789868e-01
+ 1.243700000000e-05 7.588872582020e-01
+ 1.243800000000e-05 7.589482374173e-01
+ 1.243900000000e-05 7.590092166325e-01
+ 1.244000000000e-05 7.590701958477e-01
+ 1.244100000000e-05 7.591311750629e-01
+ 1.244200000000e-05 7.591921542781e-01
+ 1.244300000000e-05 7.592531334933e-01
+ 1.244400000000e-05 7.593141127086e-01
+ 1.244500000000e-05 7.593750919238e-01
+ 1.244600000000e-05 7.594360711390e-01
+ 1.244700000000e-05 7.594970503542e-01
+ 1.244800000000e-05 7.595580295694e-01
+ 1.244900000000e-05 7.596190087846e-01
+ 1.245000000000e-05 7.596799879999e-01
+ 1.245100000000e-05 7.597409672151e-01
+ 1.245200000000e-05 7.598019464303e-01
+ 1.245300000000e-05 7.598629256455e-01
+ 1.245400000000e-05 7.599239048607e-01
+ 1.245500000000e-05 7.599848840759e-01
+ 1.245600000000e-05 7.600458632912e-01
+ 1.245700000000e-05 7.601068425064e-01
+ 1.245800000000e-05 7.601678217216e-01
+ 1.245900000000e-05 7.602288009368e-01
+ 1.246000000000e-05 7.602897801520e-01
+ 1.246100000000e-05 7.603507593672e-01
+ 1.246200000000e-05 7.604117385825e-01
+ 1.246300000000e-05 7.604727177977e-01
+ 1.246400000000e-05 7.605336970129e-01
+ 1.246500000000e-05 7.605946762281e-01
+ 1.246600000000e-05 7.606556554433e-01
+ 1.246700000000e-05 7.607166346585e-01
+ 1.246800000000e-05 7.607776138738e-01
+ 1.246900000000e-05 7.608385930890e-01
+ 1.247000000000e-05 7.608995723042e-01
+ 1.247100000000e-05 7.609605515194e-01
+ 1.247200000000e-05 7.610215307346e-01
+ 1.247300000000e-05 7.610825099498e-01
+ 1.247400000000e-05 7.611434891651e-01
+ 1.247500000000e-05 7.612044683803e-01
+ 1.247600000000e-05 7.612654475955e-01
+ 1.247700000000e-05 7.613264268107e-01
+ 1.247800000000e-05 7.613874060259e-01
+ 1.247900000000e-05 7.614483852411e-01
+ 1.248000000000e-05 7.615093644564e-01
+ 1.248100000000e-05 7.615703436716e-01
+ 1.248200000000e-05 7.616313228868e-01
+ 1.248300000000e-05 7.616923021020e-01
+ 1.248400000000e-05 7.617532813172e-01
+ 1.248500000000e-05 7.618142605324e-01
+ 1.248600000000e-05 7.618752397477e-01
+ 1.248700000000e-05 7.619362189629e-01
+ 1.248800000000e-05 7.619971981781e-01
+ 1.248900000000e-05 7.620581773933e-01
+ 1.249000000000e-05 7.621191566085e-01
+ 1.249100000000e-05 7.621801358237e-01
+ 1.249200000000e-05 7.622411150390e-01
+ 1.249300000000e-05 7.623020942542e-01
+ 1.249400000000e-05 7.623630734694e-01
+ 1.249500000000e-05 7.624240526846e-01
+ 1.249600000000e-05 7.624850318998e-01
+ 1.249700000000e-05 7.625460111150e-01
+ 1.249800000000e-05 7.626069903303e-01
+ 1.249900000000e-05 7.626679695455e-01
+ 1.250000000000e-05 7.627289487607e-01
+ 1.250100000000e-05 7.627899279759e-01
+ 1.250200000000e-05 7.628509071911e-01
+ 1.250300000000e-05 7.629118864063e-01
+ 1.250400000000e-05 7.629728656216e-01
+ 1.250500000000e-05 7.630338448368e-01
+ 1.250600000000e-05 7.630948240520e-01
+ 1.250700000000e-05 7.631558032672e-01
+ 1.250800000000e-05 7.632167824824e-01
+ 1.250900000000e-05 7.632777616976e-01
+ 1.251000000000e-05 7.633387409129e-01
+ 1.251100000000e-05 7.633997201281e-01
+ 1.251200000000e-05 7.634606993433e-01
+ 1.251300000000e-05 7.635216785585e-01
+ 1.251400000000e-05 7.635826577737e-01
+ 1.251500000000e-05 7.636436369889e-01
+ 1.251600000000e-05 7.637046162042e-01
+ 1.251700000000e-05 7.637655954194e-01
+ 1.251800000000e-05 7.638265746346e-01
+ 1.251900000000e-05 7.638875538498e-01
+ 1.252000000000e-05 7.639485330650e-01
+ 1.252100000000e-05 7.640095122802e-01
+ 1.252200000000e-05 7.640704914955e-01
+ 1.252300000000e-05 7.641314707107e-01
+ 1.252400000000e-05 7.641924499259e-01
+ 1.252500000000e-05 7.642534291411e-01
+ 1.252600000000e-05 7.643144083563e-01
+ 1.252700000000e-05 7.643753875715e-01
+ 1.252800000000e-05 7.644363667868e-01
+ 1.252900000000e-05 7.644973460020e-01
+ 1.253000000000e-05 7.645583252172e-01
+ 1.253100000000e-05 7.646193044324e-01
+ 1.253200000000e-05 7.646802836476e-01
+ 1.253300000000e-05 7.647412628628e-01
+ 1.253400000000e-05 7.648022420781e-01
+ 1.253500000000e-05 7.648632212933e-01
+ 1.253600000000e-05 7.649242005085e-01
+ 1.253700000000e-05 7.649851797237e-01
+ 1.253800000000e-05 7.650461589389e-01
+ 1.253900000000e-05 7.651071381541e-01
+ 1.254000000000e-05 7.651681173694e-01
+ 1.254100000000e-05 7.652290965846e-01
+ 1.254200000000e-05 7.652900757998e-01
+ 1.254300000000e-05 7.653510550150e-01
+ 1.254400000000e-05 7.654120342302e-01
+ 1.254500000000e-05 7.654730134454e-01
+ 1.254600000000e-05 7.655339926607e-01
+ 1.254700000000e-05 7.655949718759e-01
+ 1.254800000000e-05 7.656559510911e-01
+ 1.254900000000e-05 7.657169303063e-01
+ 1.255000000000e-05 7.657779095215e-01
+ 1.255100000000e-05 7.658388887367e-01
+ 1.255200000000e-05 7.658998679520e-01
+ 1.255300000000e-05 7.659608471672e-01
+ 1.255400000000e-05 7.660218263824e-01
+ 1.255500000000e-05 7.660828055976e-01
+ 1.255600000000e-05 7.661437848128e-01
+ 1.255700000000e-05 7.662047640280e-01
+ 1.255800000000e-05 7.662657432433e-01
+ 1.255900000000e-05 7.663267224585e-01
+ 1.256000000000e-05 7.663877016737e-01
+ 1.256100000000e-05 7.664486808889e-01
+ 1.256200000000e-05 7.665096601041e-01
+ 1.256300000000e-05 7.665706393193e-01
+ 1.256400000000e-05 7.666316185346e-01
+ 1.256500000000e-05 7.666925977498e-01
+ 1.256600000000e-05 7.667535769650e-01
+ 1.256700000000e-05 7.668145561802e-01
+ 1.256800000000e-05 7.668755353954e-01
+ 1.256900000000e-05 7.669365146106e-01
+ 1.257000000000e-05 7.669974938259e-01
+ 1.257100000000e-05 7.670584730411e-01
+ 1.257200000000e-05 7.671194522563e-01
+ 1.257300000000e-05 7.671804314715e-01
+ 1.257400000000e-05 7.672414106867e-01
+ 1.257500000000e-05 7.673023899019e-01
+ 1.257600000000e-05 7.673633691172e-01
+ 1.257700000000e-05 7.674243483324e-01
+ 1.257800000000e-05 7.674853275476e-01
+ 1.257900000000e-05 7.675463067628e-01
+ 1.258000000000e-05 7.676072859780e-01
+ 1.258100000000e-05 7.676682651932e-01
+ 1.258200000000e-05 7.677292444085e-01
+ 1.258300000000e-05 7.677902236237e-01
+ 1.258400000000e-05 7.678512028389e-01
+ 1.258500000000e-05 7.679121820541e-01
+ 1.258600000000e-05 7.679731612693e-01
+ 1.258700000000e-05 7.680341404845e-01
+ 1.258800000000e-05 7.680951196998e-01
+ 1.258900000000e-05 7.681560989150e-01
+ 1.259000000000e-05 7.682170781302e-01
+ 1.259100000000e-05 7.682780573454e-01
+ 1.259200000000e-05 7.683390365606e-01
+ 1.259300000000e-05 7.684000157758e-01
+ 1.259400000000e-05 7.684609949911e-01
+ 1.259500000000e-05 7.685219742063e-01
+ 1.259600000000e-05 7.685829534215e-01
+ 1.259700000000e-05 7.686439326367e-01
+ 1.259800000000e-05 7.687049118519e-01
+ 1.259900000000e-05 7.687658910671e-01
+ 1.260000000000e-05 7.688268702824e-01
+ 1.260100000000e-05 7.688878494976e-01
+ 1.260200000000e-05 7.689488287128e-01
+ 1.260300000000e-05 7.690098079280e-01
+ 1.260400000000e-05 7.690707871432e-01
+ 1.260500000000e-05 7.691317663584e-01
+ 1.260600000000e-05 7.691927455737e-01
+ 1.260700000000e-05 7.692537247889e-01
+ 1.260800000000e-05 7.693147040041e-01
+ 1.260900000000e-05 7.693756832193e-01
+ 1.261000000000e-05 7.694366624345e-01
+ 1.261100000000e-05 7.694976416497e-01
+ 1.261200000000e-05 7.695586208650e-01
+ 1.261300000000e-05 7.696196000802e-01
+ 1.261400000000e-05 7.696805792954e-01
+ 1.261500000000e-05 7.697415585106e-01
+ 1.261600000000e-05 7.698025377258e-01
+ 1.261700000000e-05 7.698635169410e-01
+ 1.261800000000e-05 7.699244961563e-01
+ 1.261900000000e-05 7.699854753715e-01
+ 1.262000000000e-05 7.700464545867e-01
+ 1.262100000000e-05 7.701074338019e-01
+ 1.262200000000e-05 7.701684130171e-01
+ 1.262300000000e-05 7.702293922323e-01
+ 1.262400000000e-05 7.702903714476e-01
+ 1.262500000000e-05 7.703513506628e-01
+ 1.262600000000e-05 7.704123298780e-01
+ 1.262700000000e-05 7.704733090932e-01
+ 1.262800000000e-05 7.705342883084e-01
+ 1.262900000000e-05 7.705952675236e-01
+ 1.263000000000e-05 7.706562467389e-01
+ 1.263100000000e-05 7.707172259541e-01
+ 1.263200000000e-05 7.707782051693e-01
+ 1.263300000000e-05 7.708391843845e-01
+ 1.263400000000e-05 7.709001635997e-01
+ 1.263500000000e-05 7.709611428149e-01
+ 1.263600000000e-05 7.710221220301e-01
+ 1.263700000000e-05 7.710831012454e-01
+ 1.263800000000e-05 7.711440804606e-01
+ 1.263900000000e-05 7.712050596758e-01
+ 1.264000000000e-05 7.712660388910e-01
+ 1.264100000000e-05 7.713270181062e-01
+ 1.264200000000e-05 7.713879973214e-01
+ 1.264300000000e-05 7.714489765367e-01
+ 1.264400000000e-05 7.715099557519e-01
+ 1.264500000000e-05 7.715709349671e-01
+ 1.264600000000e-05 7.716319141823e-01
+ 1.264700000000e-05 7.716928933975e-01
+ 1.264800000000e-05 7.717538726127e-01
+ 1.264900000000e-05 7.718148518280e-01
+ 1.265000000000e-05 7.718758310432e-01
+ 1.265100000000e-05 7.719368102584e-01
+ 1.265200000000e-05 7.719977894736e-01
+ 1.265300000000e-05 7.720587686888e-01
+ 1.265400000000e-05 7.721197479040e-01
+ 1.265500000000e-05 7.721807271193e-01
+ 1.265600000000e-05 7.722417063345e-01
+ 1.265700000000e-05 7.723026855497e-01
+ 1.265800000000e-05 7.723636647649e-01
+ 1.265900000000e-05 7.724246439801e-01
+ 1.266000000000e-05 7.724856231953e-01
+ 1.266100000000e-05 7.725466024106e-01
+ 1.266200000000e-05 7.726075816258e-01
+ 1.266300000000e-05 7.726685608410e-01
+ 1.266400000000e-05 7.727295400562e-01
+ 1.266500000000e-05 7.727905192714e-01
+ 1.266600000000e-05 7.728514984866e-01
+ 1.266700000000e-05 7.729124777019e-01
+ 1.266800000000e-05 7.729734569171e-01
+ 1.266900000000e-05 7.730344361323e-01
+ 1.267000000000e-05 7.730954153475e-01
+ 1.267100000000e-05 7.731563945627e-01
+ 1.267200000000e-05 7.732173737779e-01
+ 1.267300000000e-05 7.732783529932e-01
+ 1.267400000000e-05 7.733393322084e-01
+ 1.267500000000e-05 7.734003114236e-01
+ 1.267600000000e-05 7.734612906388e-01
+ 1.267700000000e-05 7.735222698540e-01
+ 1.267800000000e-05 7.735832490692e-01
+ 1.267900000000e-05 7.736442282845e-01
+ 1.268000000000e-05 7.737052074997e-01
+ 1.268100000000e-05 7.737661867149e-01
+ 1.268200000000e-05 7.738271659301e-01
+ 1.268300000000e-05 7.738881451453e-01
+ 1.268400000000e-05 7.739491243605e-01
+ 1.268500000000e-05 7.740101035758e-01
+ 1.268600000000e-05 7.740710827910e-01
+ 1.268700000000e-05 7.741320620062e-01
+ 1.268800000000e-05 7.741930412214e-01
+ 1.268900000000e-05 7.742540204366e-01
+ 1.269000000000e-05 7.743149996518e-01
+ 1.269100000000e-05 7.743759788671e-01
+ 1.269200000000e-05 7.744369580823e-01
+ 1.269300000000e-05 7.744979372975e-01
+ 1.269400000000e-05 7.745589165127e-01
+ 1.269500000000e-05 7.746198957279e-01
+ 1.269600000000e-05 7.746808749431e-01
+ 1.269700000000e-05 7.747418541584e-01
+ 1.269800000000e-05 7.748028333736e-01
+ 1.269900000000e-05 7.748638125888e-01
+ 1.270000000000e-05 7.749247918040e-01
+ 1.270100000000e-05 7.749857710192e-01
+ 1.270200000000e-05 7.750467502344e-01
+ 1.270300000000e-05 7.751077294497e-01
+ 1.270400000000e-05 7.751687086649e-01
+ 1.270500000000e-05 7.752296878801e-01
+ 1.270600000000e-05 7.752906670953e-01
+ 1.270700000000e-05 7.753516463105e-01
+ 1.270800000000e-05 7.754126255257e-01
+ 1.270900000000e-05 7.754736047410e-01
+ 1.271000000000e-05 7.755345839562e-01
+ 1.271100000000e-05 7.755955631714e-01
+ 1.271200000000e-05 7.756565423866e-01
+ 1.271300000000e-05 7.757175216018e-01
+ 1.271400000000e-05 7.757785008170e-01
+ 1.271500000000e-05 7.758394800323e-01
+ 1.271600000000e-05 7.759004592475e-01
+ 1.271700000000e-05 7.759614384627e-01
+ 1.271800000000e-05 7.760224176779e-01
+ 1.271900000000e-05 7.760833968931e-01
+ 1.272000000000e-05 7.761443761083e-01
+ 1.272100000000e-05 7.762053553236e-01
+ 1.272200000000e-05 7.762663345388e-01
+ 1.272300000000e-05 7.763273137540e-01
+ 1.272400000000e-05 7.763882929692e-01
+ 1.272500000000e-05 7.764492721844e-01
+ 1.272600000000e-05 7.765102513996e-01
+ 1.272700000000e-05 7.765712306149e-01
+ 1.272800000000e-05 7.766322098301e-01
+ 1.272900000000e-05 7.766931890453e-01
+ 1.273000000000e-05 7.767541682605e-01
+ 1.273100000000e-05 7.768151474757e-01
+ 1.273200000000e-05 7.768761266909e-01
+ 1.273300000000e-05 7.769371059062e-01
+ 1.273400000000e-05 7.769980851214e-01
+ 1.273500000000e-05 7.770590643366e-01
+ 1.273600000000e-05 7.771200435518e-01
+ 1.273700000000e-05 7.771810227670e-01
+ 1.273800000000e-05 7.772420019822e-01
+ 1.273900000000e-05 7.773029811975e-01
+ 1.274000000000e-05 7.773639604127e-01
+ 1.274100000000e-05 7.774249396279e-01
+ 1.274200000000e-05 7.774859188431e-01
+ 1.274300000000e-05 7.775468980583e-01
+ 1.274400000000e-05 7.776078772735e-01
+ 1.274500000000e-05 7.776688564888e-01
+ 1.274600000000e-05 7.777298357040e-01
+ 1.274700000000e-05 7.777908149192e-01
+ 1.274800000000e-05 7.778517941344e-01
+ 1.274900000000e-05 7.779127733496e-01
+ 1.275000000000e-05 7.779737525648e-01
+ 1.275100000000e-05 7.780347317801e-01
+ 1.275200000000e-05 7.780957109953e-01
+ 1.275300000000e-05 7.781566902105e-01
+ 1.275400000000e-05 7.782176694257e-01
+ 1.275500000000e-05 7.782786486409e-01
+ 1.275600000000e-05 7.783396278561e-01
+ 1.275700000000e-05 7.784006070714e-01
+ 1.275800000000e-05 7.784615862866e-01
+ 1.275900000000e-05 7.785225655018e-01
+ 1.276000000000e-05 7.785835447170e-01
+ 1.276100000000e-05 7.786445239322e-01
+ 1.276200000000e-05 7.787055031474e-01
+ 1.276300000000e-05 7.787664823627e-01
+ 1.276400000000e-05 7.788274615779e-01
+ 1.276500000000e-05 7.788884407931e-01
+ 1.276600000000e-05 7.789494200083e-01
+ 1.276700000000e-05 7.790103992235e-01
+ 1.276800000000e-05 7.790713784387e-01
+ 1.276900000000e-05 7.791323576540e-01
+ 1.277000000000e-05 7.791933368692e-01
+ 1.277100000000e-05 7.792543160844e-01
+ 1.277200000000e-05 7.793152952996e-01
+ 1.277300000000e-05 7.793762745148e-01
+ 1.277400000000e-05 7.794372537300e-01
+ 1.277500000000e-05 7.794982329453e-01
+ 1.277600000000e-05 7.795592121605e-01
+ 1.277700000000e-05 7.796201913757e-01
+ 1.277800000000e-05 7.796811705909e-01
+ 1.277900000000e-05 7.797421498061e-01
+ 1.278000000000e-05 7.798031290213e-01
+ 1.278100000000e-05 7.798641082366e-01
+ 1.278200000000e-05 7.799250874518e-01
+ 1.278300000000e-05 7.799860666670e-01
+ 1.278400000000e-05 7.800470458822e-01
+ 1.278500000000e-05 7.801080250974e-01
+ 1.278600000000e-05 7.801690043126e-01
+ 1.278700000000e-05 7.802299835279e-01
+ 1.278800000000e-05 7.802909627431e-01
+ 1.278900000000e-05 7.803519419583e-01
+ 1.279000000000e-05 7.804129211735e-01
+ 1.279100000000e-05 7.804739003887e-01
+ 1.279200000000e-05 7.805348796039e-01
+ 1.279300000000e-05 7.805958588192e-01
+ 1.279400000000e-05 7.806568380344e-01
+ 1.279500000000e-05 7.807178172496e-01
+ 1.279600000000e-05 7.807787964648e-01
+ 1.279700000000e-05 7.808397756800e-01
+ 1.279800000000e-05 7.809007548952e-01
+ 1.279900000000e-05 7.809617341105e-01
+ 1.280000000000e-05 7.810227133257e-01
+ 1.280100000000e-05 7.810836925409e-01
+ 1.280200000000e-05 7.811446717561e-01
+ 1.280300000000e-05 7.812056509713e-01
+ 1.280400000000e-05 7.812666301865e-01
+ 1.280500000000e-05 7.813276094018e-01
+ 1.280600000000e-05 7.813885886170e-01
+ 1.280700000000e-05 7.814495678322e-01
+ 1.280800000000e-05 7.815105470474e-01
+ 1.280900000000e-05 7.815715262626e-01
+ 1.281000000000e-05 7.816325054778e-01
+ 1.281100000000e-05 7.816934846931e-01
+ 1.281200000000e-05 7.817544639083e-01
+ 1.281300000000e-05 7.818154431235e-01
+ 1.281400000000e-05 7.818764223387e-01
+ 1.281500000000e-05 7.819374015539e-01
+ 1.281600000000e-05 7.819983807691e-01
+ 1.281700000000e-05 7.820593599844e-01
+ 1.281800000000e-05 7.821203391996e-01
+ 1.281900000000e-05 7.821813184148e-01
+ 1.282000000000e-05 7.822422976300e-01
+ 1.282100000000e-05 7.823032768452e-01
+ 1.282200000000e-05 7.823642560604e-01
+ 1.282300000000e-05 7.824252352757e-01
+ 1.282400000000e-05 7.824862144909e-01
+ 1.282500000000e-05 7.825471937061e-01
+ 1.282600000000e-05 7.826081729213e-01
+ 1.282700000000e-05 7.826691521365e-01
+ 1.282800000000e-05 7.827301313517e-01
+ 1.282900000000e-05 7.827911105670e-01
+ 1.283000000000e-05 7.828520897822e-01
+ 1.283100000000e-05 7.829130689974e-01
+ 1.283200000000e-05 7.829740482126e-01
+ 1.283300000000e-05 7.830350274278e-01
+ 1.283400000000e-05 7.830960066430e-01
+ 1.283500000000e-05 7.831569858583e-01
+ 1.283600000000e-05 7.832179650735e-01
+ 1.283700000000e-05 7.832789442887e-01
+ 1.283800000000e-05 7.833399235039e-01
+ 1.283900000000e-05 7.834009027191e-01
+ 1.284000000000e-05 7.834618819343e-01
+ 1.284100000000e-05 7.835228611496e-01
+ 1.284200000000e-05 7.835838403648e-01
+ 1.284300000000e-05 7.836448195800e-01
+ 1.284400000000e-05 7.837057987952e-01
+ 1.284500000000e-05 7.837667780104e-01
+ 1.284600000000e-05 7.838277572256e-01
+ 1.284700000000e-05 7.838887364409e-01
+ 1.284800000000e-05 7.839497156561e-01
+ 1.284900000000e-05 7.840106948713e-01
+ 1.285000000000e-05 7.840716740865e-01
+ 1.285100000000e-05 7.841326533017e-01
+ 1.285200000000e-05 7.841936325169e-01
+ 1.285300000000e-05 7.842546117322e-01
+ 1.285400000000e-05 7.843155909474e-01
+ 1.285500000000e-05 7.843765701626e-01
+ 1.285600000000e-05 7.844375493778e-01
+ 1.285700000000e-05 7.844985285930e-01
+ 1.285800000000e-05 7.845595078082e-01
+ 1.285900000000e-05 7.846204870234e-01
+ 1.286000000000e-05 7.846814662387e-01
+ 1.286100000000e-05 7.847424454539e-01
+ 1.286200000000e-05 7.848034246691e-01
+ 1.286300000000e-05 7.848644038843e-01
+ 1.286400000000e-05 7.849253830995e-01
+ 1.286500000000e-05 7.849863623147e-01
+ 1.286600000000e-05 7.850473415300e-01
+ 1.286700000000e-05 7.851083207452e-01
+ 1.286800000000e-05 7.851692999604e-01
+ 1.286900000000e-05 7.852302791756e-01
+ 1.287000000000e-05 7.852912583908e-01
+ 1.287100000000e-05 7.853522376060e-01
+ 1.287200000000e-05 7.854132168213e-01
+ 1.287300000000e-05 7.854741960365e-01
+ 1.287400000000e-05 7.855351752517e-01
+ 1.287500000000e-05 7.855961544669e-01
+ 1.287600000000e-05 7.856571336821e-01
+ 1.287700000000e-05 7.857181128973e-01
+ 1.287800000000e-05 7.857790921126e-01
+ 1.287900000000e-05 7.858400713278e-01
+ 1.288000000000e-05 7.859010505430e-01
+ 1.288100000000e-05 7.859620297582e-01
+ 1.288200000000e-05 7.860230089734e-01
+ 1.288300000000e-05 7.860839881886e-01
+ 1.288400000000e-05 7.861449674039e-01
+ 1.288500000000e-05 7.862059466191e-01
+ 1.288600000000e-05 7.862669258343e-01
+ 1.288700000000e-05 7.863279050495e-01
+ 1.288800000000e-05 7.863888842647e-01
+ 1.288900000000e-05 7.864498634799e-01
+ 1.289000000000e-05 7.865108426952e-01
+ 1.289100000000e-05 7.865718219104e-01
+ 1.289200000000e-05 7.866328011256e-01
+ 1.289300000000e-05 7.866937803408e-01
+ 1.289400000000e-05 7.867547595560e-01
+ 1.289500000000e-05 7.868157387712e-01
+ 1.289600000000e-05 7.868767179865e-01
+ 1.289700000000e-05 7.869376972017e-01
+ 1.289800000000e-05 7.869986764169e-01
+ 1.289900000000e-05 7.870596556321e-01
+ 1.290000000000e-05 7.871206348473e-01
+ 1.290100000000e-05 7.871816140625e-01
+ 1.290200000000e-05 7.872425932778e-01
+ 1.290300000000e-05 7.873035724930e-01
+ 1.290400000000e-05 7.873645517082e-01
+ 1.290500000000e-05 7.874255309234e-01
+ 1.290600000000e-05 7.874865101386e-01
+ 1.290700000000e-05 7.875474893538e-01
+ 1.290800000000e-05 7.876084685691e-01
+ 1.290900000000e-05 7.876694477843e-01
+ 1.291000000000e-05 7.877304269995e-01
+ 1.291100000000e-05 7.877914062147e-01
+ 1.291200000000e-05 7.878523854299e-01
+ 1.291300000000e-05 7.879133646451e-01
+ 1.291400000000e-05 7.879743438604e-01
+ 1.291500000000e-05 7.880353230756e-01
+ 1.291600000000e-05 7.880963022908e-01
+ 1.291700000000e-05 7.881572815060e-01
+ 1.291800000000e-05 7.882182607212e-01
+ 1.291900000000e-05 7.882792399364e-01
+ 1.292000000000e-05 7.883402191517e-01
+ 1.292100000000e-05 7.884011983669e-01
+ 1.292200000000e-05 7.884621775821e-01
+ 1.292300000000e-05 7.885231567973e-01
+ 1.292400000000e-05 7.885841360125e-01
+ 1.292500000000e-05 7.886451152277e-01
+ 1.292600000000e-05 7.887060944430e-01
+ 1.292700000000e-05 7.887670736582e-01
+ 1.292800000000e-05 7.888280528734e-01
+ 1.292900000000e-05 7.888890320886e-01
+ 1.293000000000e-05 7.889500113038e-01
+ 1.293100000000e-05 7.890109905190e-01
+ 1.293200000000e-05 7.890719697343e-01
+ 1.293300000000e-05 7.891329489495e-01
+ 1.293400000000e-05 7.891939281647e-01
+ 1.293500000000e-05 7.892549073799e-01
+ 1.293600000000e-05 7.893158865951e-01
+ 1.293700000000e-05 7.893768658103e-01
+ 1.293800000000e-05 7.894378450256e-01
+ 1.293900000000e-05 7.894988242408e-01
+ 1.294000000000e-05 7.895598034560e-01
+ 1.294100000000e-05 7.896207826712e-01
+ 1.294200000000e-05 7.896817618864e-01
+ 1.294300000000e-05 7.897427411016e-01
+ 1.294400000000e-05 7.898037203169e-01
+ 1.294500000000e-05 7.898646995321e-01
+ 1.294600000000e-05 7.899256787473e-01
+ 1.294700000000e-05 7.899866579625e-01
+ 1.294800000000e-05 7.900476371777e-01
+ 1.294900000000e-05 7.901086163929e-01
+ 1.295000000000e-05 7.901695956082e-01
+ 1.295100000000e-05 7.902305748234e-01
+ 1.295200000000e-05 7.902915540386e-01
+ 1.295300000000e-05 7.903525332538e-01
+ 1.295400000000e-05 7.904135124690e-01
+ 1.295500000000e-05 7.904744916842e-01
+ 1.295600000000e-05 7.905354708995e-01
+ 1.295700000000e-05 7.905964501147e-01
+ 1.295800000000e-05 7.906574293299e-01
+ 1.295900000000e-05 7.907184085451e-01
+ 1.296000000000e-05 7.907793877603e-01
+ 1.296100000000e-05 7.908403669755e-01
+ 1.296200000000e-05 7.909013461908e-01
+ 1.296300000000e-05 7.909623254060e-01
+ 1.296400000000e-05 7.910233046212e-01
+ 1.296500000000e-05 7.910842838364e-01
+ 1.296600000000e-05 7.911452630516e-01
+ 1.296700000000e-05 7.912062422668e-01
+ 1.296800000000e-05 7.912672214821e-01
+ 1.296900000000e-05 7.913282006973e-01
+ 1.297000000000e-05 7.913891799125e-01
+ 1.297100000000e-05 7.914501591277e-01
+ 1.297200000000e-05 7.915111383429e-01
+ 1.297300000000e-05 7.915721175581e-01
+ 1.297400000000e-05 7.916330967734e-01
+ 1.297500000000e-05 7.916940759886e-01
+ 1.297600000000e-05 7.917550552038e-01
+ 1.297700000000e-05 7.918160344190e-01
+ 1.297800000000e-05 7.918770136342e-01
+ 1.297900000000e-05 7.919379928494e-01
+ 1.298000000000e-05 7.919989720647e-01
+ 1.298100000000e-05 7.920599512799e-01
+ 1.298200000000e-05 7.921209304951e-01
+ 1.298300000000e-05 7.921819097103e-01
+ 1.298400000000e-05 7.922428889255e-01
+ 1.298500000000e-05 7.923038681407e-01
+ 1.298600000000e-05 7.923648473560e-01
+ 1.298700000000e-05 7.924258265712e-01
+ 1.298800000000e-05 7.924868057864e-01
+ 1.298900000000e-05 7.925477850016e-01
+ 1.299000000000e-05 7.926087642168e-01
+ 1.299100000000e-05 7.926697434320e-01
+ 1.299200000000e-05 7.927307226473e-01
+ 1.299300000000e-05 7.927917018625e-01
+ 1.299400000000e-05 7.928526810777e-01
+ 1.299500000000e-05 7.929136602929e-01
+ 1.299600000000e-05 7.929746395081e-01
+ 1.299700000000e-05 7.930356187233e-01
+ 1.299800000000e-05 7.930965979386e-01
+ 1.299900000000e-05 7.931575771538e-01
+ 1.300000000000e-05 7.932185563690e-01
+ 1.300100000000e-05 7.932795355842e-01
+ 1.300200000000e-05 7.933405147994e-01
+ 1.300300000000e-05 7.934014940146e-01
+ 1.300400000000e-05 7.934624732299e-01
+ 1.300500000000e-05 7.935234524451e-01
+ 1.300600000000e-05 7.935844316603e-01
+ 1.300700000000e-05 7.936454108755e-01
+ 1.300800000000e-05 7.937063900907e-01
+ 1.300900000000e-05 7.937673693059e-01
+ 1.301000000000e-05 7.938283485212e-01
+ 1.301100000000e-05 7.938893277364e-01
+ 1.301200000000e-05 7.939503069516e-01
+ 1.301300000000e-05 7.940112861668e-01
+ 1.301400000000e-05 7.940722653820e-01
+ 1.301500000000e-05 7.941332445972e-01
+ 1.301600000000e-05 7.941942238125e-01
+ 1.301700000000e-05 7.942552030277e-01
+ 1.301800000000e-05 7.943161822429e-01
+ 1.301900000000e-05 7.943771614581e-01
+ 1.302000000000e-05 7.944381406733e-01
+ 1.302100000000e-05 7.944991198885e-01
+ 1.302200000000e-05 7.945600991038e-01
+ 1.302300000000e-05 7.946210783190e-01
+ 1.302400000000e-05 7.946820575342e-01
+ 1.302500000000e-05 7.947430367494e-01
+ 1.302600000000e-05 7.948040159646e-01
+ 1.302700000000e-05 7.948649951798e-01
+ 1.302800000000e-05 7.949259743951e-01
+ 1.302900000000e-05 7.949869536103e-01
+ 1.303000000000e-05 7.950479328255e-01
+ 1.303100000000e-05 7.951089120407e-01
+ 1.303200000000e-05 7.951698912559e-01
+ 1.303300000000e-05 7.952308704711e-01
+ 1.303400000000e-05 7.952918496864e-01
+ 1.303500000000e-05 7.953528289016e-01
+ 1.303600000000e-05 7.954138081168e-01
+ 1.303700000000e-05 7.954747873320e-01
+ 1.303800000000e-05 7.955357665472e-01
+ 1.303900000000e-05 7.955967457624e-01
+ 1.304000000000e-05 7.956577249777e-01
+ 1.304100000000e-05 7.957187041929e-01
+ 1.304200000000e-05 7.957796834081e-01
+ 1.304300000000e-05 7.958406626233e-01
+ 1.304400000000e-05 7.959016418385e-01
+ 1.304500000000e-05 7.959626210537e-01
+ 1.304600000000e-05 7.960236002690e-01
+ 1.304700000000e-05 7.960845794842e-01
+ 1.304800000000e-05 7.961455586994e-01
+ 1.304900000000e-05 7.962065379146e-01
+ 1.305000000000e-05 7.962675171298e-01
+ 1.305100000000e-05 7.963284963450e-01
+ 1.305200000000e-05 7.963894755603e-01
+ 1.305300000000e-05 7.964504547755e-01
+ 1.305400000000e-05 7.965114339907e-01
+ 1.305500000000e-05 7.965724132059e-01
+ 1.305600000000e-05 7.966333924211e-01
+ 1.305700000000e-05 7.966943716363e-01
+ 1.305800000000e-05 7.967553508516e-01
+ 1.305900000000e-05 7.968163300668e-01
+ 1.306000000000e-05 7.968773092820e-01
+ 1.306100000000e-05 7.969382884972e-01
+ 1.306200000000e-05 7.969992677124e-01
+ 1.306300000000e-05 7.970602469276e-01
+ 1.306400000000e-05 7.971212261429e-01
+ 1.306500000000e-05 7.971822053581e-01
+ 1.306600000000e-05 7.972431845733e-01
+ 1.306700000000e-05 7.973041637885e-01
+ 1.306800000000e-05 7.973651430037e-01
+ 1.306900000000e-05 7.974261222189e-01
+ 1.307000000000e-05 7.974871014342e-01
+ 1.307100000000e-05 7.975480806494e-01
+ 1.307200000000e-05 7.976090598646e-01
+ 1.307300000000e-05 7.976700390798e-01
+ 1.307400000000e-05 7.977310182950e-01
+ 1.307500000000e-05 7.977919975102e-01
+ 1.307600000000e-05 7.978529767255e-01
+ 1.307700000000e-05 7.979139559407e-01
+ 1.307800000000e-05 7.979749351559e-01
+ 1.307900000000e-05 7.980359143711e-01
+ 1.308000000000e-05 7.980968935863e-01
+ 1.308100000000e-05 7.981578728015e-01
+ 1.308200000000e-05 7.982188520168e-01
+ 1.308300000000e-05 7.982798312320e-01
+ 1.308400000000e-05 7.983408104472e-01
+ 1.308500000000e-05 7.984017896624e-01
+ 1.308600000000e-05 7.984627688776e-01
+ 1.308700000000e-05 7.985237480928e-01
+ 1.308800000000e-05 7.985847273080e-01
+ 1.308900000000e-05 7.986457065233e-01
+ 1.309000000000e-05 7.987066857385e-01
+ 1.309100000000e-05 7.987676649537e-01
+ 1.309200000000e-05 7.988286441689e-01
+ 1.309300000000e-05 7.988896233841e-01
+ 1.309400000000e-05 7.989506025993e-01
+ 1.309500000000e-05 7.990115818146e-01
+ 1.309600000000e-05 7.990725610298e-01
+ 1.309700000000e-05 7.991335402450e-01
+ 1.309800000000e-05 7.991945194602e-01
+ 1.309900000000e-05 7.992554986754e-01
+ 1.310000000000e-05 7.993164778906e-01
+ 1.310100000000e-05 7.993774571059e-01
+ 1.310200000000e-05 7.994384363211e-01
+ 1.310300000000e-05 7.994994155363e-01
+ 1.310400000000e-05 7.995603947515e-01
+ 1.310500000000e-05 7.996213739667e-01
+ 1.310600000000e-05 7.996823531819e-01
+ 1.310700000000e-05 7.997433323972e-01
+ 1.310800000000e-05 7.998043116124e-01
+ 1.310900000000e-05 7.998652908276e-01
+ 1.311000000000e-05 7.999262700428e-01
+ 1.311100000000e-05 7.999872492580e-01
+ 1.311200000000e-05 8.000482284732e-01
+ 1.311300000000e-05 8.001092076885e-01
+ 1.311400000000e-05 8.001701869037e-01
+ 1.311500000000e-05 8.002311661189e-01
+ 1.311600000000e-05 8.002921453341e-01
+ 1.311700000000e-05 8.003531245493e-01
+ 1.311800000000e-05 8.004141037645e-01
+ 1.311900000000e-05 8.004750829798e-01
+ 1.312000000000e-05 8.005360621950e-01
+ 1.312100000000e-05 8.005970414102e-01
+ 1.312200000000e-05 8.006580206254e-01
+ 1.312300000000e-05 8.007189998406e-01
+ 1.312400000000e-05 8.007799790558e-01
+ 1.312500000000e-05 8.008409582711e-01
+ 1.312600000000e-05 8.009019374863e-01
+ 1.312700000000e-05 8.009629167015e-01
+ 1.312800000000e-05 8.010238959167e-01
+ 1.312900000000e-05 8.010848751319e-01
+ 1.313000000000e-05 8.011458543471e-01
+ 1.313100000000e-05 8.012068335624e-01
+ 1.313200000000e-05 8.012678127776e-01
+ 1.313300000000e-05 8.013287919928e-01
+ 1.313400000000e-05 8.013897712080e-01
+ 1.313500000000e-05 8.014507504232e-01
+ 1.313600000000e-05 8.015117296384e-01
+ 1.313700000000e-05 8.015727088537e-01
+ 1.313800000000e-05 8.016336880689e-01
+ 1.313900000000e-05 8.016946672841e-01
+ 1.314000000000e-05 8.017556464993e-01
+ 1.314100000000e-05 8.018166257145e-01
+ 1.314200000000e-05 8.018776049297e-01
+ 1.314300000000e-05 8.019385841450e-01
+ 1.314400000000e-05 8.019995633602e-01
+ 1.314500000000e-05 8.020605425754e-01
+ 1.314600000000e-05 8.021215217906e-01
+ 1.314700000000e-05 8.021825010058e-01
+ 1.314800000000e-05 8.022434802210e-01
+ 1.314900000000e-05 8.023044594363e-01
+ 1.315000000000e-05 8.023654386515e-01
+ 1.315100000000e-05 8.024264178667e-01
+ 1.315200000000e-05 8.024873970819e-01
+ 1.315300000000e-05 8.025483762971e-01
+ 1.315400000000e-05 8.026093555123e-01
+ 1.315500000000e-05 8.026703347276e-01
+ 1.315600000000e-05 8.027313139428e-01
+ 1.315700000000e-05 8.027922931580e-01
+ 1.315800000000e-05 8.028532723732e-01
+ 1.315900000000e-05 8.029142515884e-01
+ 1.316000000000e-05 8.029752308036e-01
+ 1.316100000000e-05 8.030362100189e-01
+ 1.316200000000e-05 8.030971892341e-01
+ 1.316300000000e-05 8.031581684493e-01
+ 1.316400000000e-05 8.032191476645e-01
+ 1.316500000000e-05 8.032801268797e-01
+ 1.316600000000e-05 8.033411060949e-01
+ 1.316700000000e-05 8.034020853102e-01
+ 1.316800000000e-05 8.034630645254e-01
+ 1.316900000000e-05 8.035240437406e-01
+ 1.317000000000e-05 8.035850229558e-01
+ 1.317100000000e-05 8.036460021710e-01
+ 1.317200000000e-05 8.037069813862e-01
+ 1.317300000000e-05 8.037679606015e-01
+ 1.317400000000e-05 8.038289398167e-01
+ 1.317500000000e-05 8.038899190319e-01
+ 1.317600000000e-05 8.039508982471e-01
+ 1.317700000000e-05 8.040118774623e-01
+ 1.317800000000e-05 8.040728566775e-01
+ 1.317900000000e-05 8.041338358928e-01
+ 1.318000000000e-05 8.041948151080e-01
+ 1.318100000000e-05 8.042557943232e-01
+ 1.318200000000e-05 8.043167735384e-01
+ 1.318300000000e-05 8.043777527536e-01
+ 1.318400000000e-05 8.044387319688e-01
+ 1.318500000000e-05 8.044997111841e-01
+ 1.318600000000e-05 8.045606903993e-01
+ 1.318700000000e-05 8.046216696145e-01
+ 1.318800000000e-05 8.046826488297e-01
+ 1.318900000000e-05 8.047436280449e-01
+ 1.319000000000e-05 8.048046072601e-01
+ 1.319100000000e-05 8.048655864754e-01
+ 1.319200000000e-05 8.049265656906e-01
+ 1.319300000000e-05 8.049875449058e-01
+ 1.319400000000e-05 8.050485241210e-01
+ 1.319500000000e-05 8.051095033362e-01
+ 1.319600000000e-05 8.051704825514e-01
+ 1.319700000000e-05 8.052314617667e-01
+ 1.319800000000e-05 8.052924409819e-01
+ 1.319900000000e-05 8.053534201971e-01
+ 1.320000000000e-05 8.054143994123e-01
+ 1.320100000000e-05 8.054753786275e-01
+ 1.320200000000e-05 8.055363578427e-01
+ 1.320300000000e-05 8.055973370580e-01
+ 1.320400000000e-05 8.056583162732e-01
+ 1.320500000000e-05 8.057192954884e-01
+ 1.320600000000e-05 8.057802747036e-01
+ 1.320700000000e-05 8.058412539188e-01
+ 1.320800000000e-05 8.059022331340e-01
+ 1.320900000000e-05 8.059632123493e-01
+ 1.321000000000e-05 8.060241915645e-01
+ 1.321100000000e-05 8.060851707797e-01
+ 1.321200000000e-05 8.061461499949e-01
+ 1.321300000000e-05 8.062071292101e-01
+ 1.321400000000e-05 8.062681084253e-01
+ 1.321500000000e-05 8.063290876406e-01
+ 1.321600000000e-05 8.063900668558e-01
+ 1.321700000000e-05 8.064510460710e-01
+ 1.321800000000e-05 8.065120252862e-01
+ 1.321900000000e-05 8.065730045014e-01
+ 1.322000000000e-05 8.066339837166e-01
+ 1.322100000000e-05 8.066949629319e-01
+ 1.322200000000e-05 8.067559421471e-01
+ 1.322300000000e-05 8.068169213623e-01
+ 1.322400000000e-05 8.068779005775e-01
+ 1.322500000000e-05 8.069388797927e-01
+ 1.322600000000e-05 8.069998590079e-01
+ 1.322700000000e-05 8.070608382232e-01
+ 1.322800000000e-05 8.071218174384e-01
+ 1.322900000000e-05 8.071827966536e-01
+ 1.323000000000e-05 8.072437758688e-01
+ 1.323100000000e-05 8.073047550840e-01
+ 1.323200000000e-05 8.073657342992e-01
+ 1.323300000000e-05 8.074267135145e-01
+ 1.323400000000e-05 8.074876927297e-01
+ 1.323500000000e-05 8.075486719449e-01
+ 1.323600000000e-05 8.076096511601e-01
+ 1.323700000000e-05 8.076706303753e-01
+ 1.323800000000e-05 8.077316095905e-01
+ 1.323900000000e-05 8.077925888058e-01
+ 1.324000000000e-05 8.078535680210e-01
+ 1.324100000000e-05 8.079145472362e-01
+ 1.324200000000e-05 8.079755264514e-01
+ 1.324300000000e-05 8.080365056666e-01
+ 1.324400000000e-05 8.080974848818e-01
+ 1.324500000000e-05 8.081584640971e-01
+ 1.324600000000e-05 8.082194433123e-01
+ 1.324700000000e-05 8.082804225275e-01
+ 1.324800000000e-05 8.083414017427e-01
+ 1.324900000000e-05 8.084023809579e-01
+ 1.325000000000e-05 8.084633601731e-01
+ 1.325100000000e-05 8.085243393884e-01
+ 1.325200000000e-05 8.085853186036e-01
+ 1.325300000000e-05 8.086462978188e-01
+ 1.325400000000e-05 8.087072770340e-01
+ 1.325500000000e-05 8.087682562492e-01
+ 1.325600000000e-05 8.088292354644e-01
+ 1.325700000000e-05 8.088902146797e-01
+ 1.325800000000e-05 8.089511938949e-01
+ 1.325900000000e-05 8.090121731101e-01
+ 1.326000000000e-05 8.090731523253e-01
+ 1.326100000000e-05 8.091341315405e-01
+ 1.326200000000e-05 8.091951107557e-01
+ 1.326300000000e-05 8.092560899710e-01
+ 1.326400000000e-05 8.093170691862e-01
+ 1.326500000000e-05 8.093780484014e-01
+ 1.326600000000e-05 8.094390276166e-01
+ 1.326700000000e-05 8.095000068318e-01
+ 1.326800000000e-05 8.095609860470e-01
+ 1.326900000000e-05 8.096219652623e-01
+ 1.327000000000e-05 8.096829444775e-01
+ 1.327100000000e-05 8.097439236927e-01
+ 1.327200000000e-05 8.098049029079e-01
+ 1.327300000000e-05 8.098658821231e-01
+ 1.327400000000e-05 8.099268613383e-01
+ 1.327500000000e-05 8.099878405536e-01
+ 1.327600000000e-05 8.100488197688e-01
+ 1.327700000000e-05 8.101097989840e-01
+ 1.327800000000e-05 8.101707781992e-01
+ 1.327900000000e-05 8.102317574144e-01
+ 1.328000000000e-05 8.102927366296e-01
+ 1.328100000000e-05 8.103537158449e-01
+ 1.328200000000e-05 8.104146950601e-01
+ 1.328300000000e-05 8.104756742753e-01
+ 1.328400000000e-05 8.105366534905e-01
+ 1.328500000000e-05 8.105976327057e-01
+ 1.328600000000e-05 8.106586119209e-01
+ 1.328700000000e-05 8.107195911362e-01
+ 1.328800000000e-05 8.107805703514e-01
+ 1.328900000000e-05 8.108415495666e-01
+ 1.329000000000e-05 8.109025287818e-01
+ 1.329100000000e-05 8.109635079970e-01
+ 1.329200000000e-05 8.110244872122e-01
+ 1.329300000000e-05 8.110854664275e-01
+ 1.329400000000e-05 8.111464456427e-01
+ 1.329500000000e-05 8.112074248579e-01
+ 1.329600000000e-05 8.112684040731e-01
+ 1.329700000000e-05 8.113293832883e-01
+ 1.329800000000e-05 8.113903625035e-01
+ 1.329900000000e-05 8.114513417188e-01
+ 1.330000000000e-05 8.115123209340e-01
+ 1.330100000000e-05 8.115733001492e-01
+ 1.330200000000e-05 8.116342793644e-01
+ 1.330300000000e-05 8.116952585796e-01
+ 1.330400000000e-05 8.117562377948e-01
+ 1.330500000000e-05 8.118172170101e-01
+ 1.330600000000e-05 8.118781962253e-01
+ 1.330700000000e-05 8.119391754405e-01
+ 1.330800000000e-05 8.120001546557e-01
+ 1.330900000000e-05 8.120611338709e-01
+ 1.331000000000e-05 8.121221130861e-01
+ 1.331100000000e-05 8.121830923014e-01
+ 1.331200000000e-05 8.122440715166e-01
+ 1.331300000000e-05 8.123050507318e-01
+ 1.331400000000e-05 8.123660299470e-01
+ 1.331500000000e-05 8.124270091622e-01
+ 1.331600000000e-05 8.124879883774e-01
+ 1.331700000000e-05 8.125489675926e-01
+ 1.331800000000e-05 8.126099468079e-01
+ 1.331900000000e-05 8.126709260231e-01
+ 1.332000000000e-05 8.127319052383e-01
+ 1.332100000000e-05 8.127928844535e-01
+ 1.332200000000e-05 8.128538636687e-01
+ 1.332300000000e-05 8.129148428839e-01
+ 1.332400000000e-05 8.129758220992e-01
+ 1.332500000000e-05 8.130368013144e-01
+ 1.332600000000e-05 8.130977805296e-01
+ 1.332700000000e-05 8.131587597448e-01
+ 1.332800000000e-05 8.132197389600e-01
+ 1.332900000000e-05 8.132807181752e-01
+ 1.333000000000e-05 8.133416973905e-01
+ 1.333100000000e-05 8.134026766057e-01
+ 1.333200000000e-05 8.134636558209e-01
+ 1.333300000000e-05 8.135246350361e-01
+ 1.333400000000e-05 8.135856142513e-01
+ 1.333500000000e-05 8.136465934665e-01
+ 1.333600000000e-05 8.137075726818e-01
+ 1.333700000000e-05 8.137685518970e-01
+ 1.333800000000e-05 8.138295311122e-01
+ 1.333900000000e-05 8.138905103274e-01
+ 1.334000000000e-05 8.139514895426e-01
+ 1.334100000000e-05 8.140124687578e-01
+ 1.334200000000e-05 8.140734479731e-01
+ 1.334300000000e-05 8.141344271883e-01
+ 1.334400000000e-05 8.141954064035e-01
+ 1.334500000000e-05 8.142563856187e-01
+ 1.334600000000e-05 8.143173648339e-01
+ 1.334700000000e-05 8.143783440491e-01
+ 1.334800000000e-05 8.144393232644e-01
+ 1.334900000000e-05 8.145003024796e-01
+ 1.335000000000e-05 8.145612816948e-01
+ 1.335100000000e-05 8.146222609100e-01
+ 1.335200000000e-05 8.146832401252e-01
+ 1.335300000000e-05 8.147442193404e-01
+ 1.335400000000e-05 8.148051985557e-01
+ 1.335500000000e-05 8.148661777709e-01
+ 1.335600000000e-05 8.149271569861e-01
+ 1.335700000000e-05 8.149881362013e-01
+ 1.335800000000e-05 8.150491154165e-01
+ 1.335900000000e-05 8.151100946317e-01
+ 1.336000000000e-05 8.151710738470e-01
+ 1.336100000000e-05 8.152320530622e-01
+ 1.336200000000e-05 8.152930322774e-01
+ 1.336300000000e-05 8.153540114926e-01
+ 1.336400000000e-05 8.154149907078e-01
+ 1.336500000000e-05 8.154759699230e-01
+ 1.336600000000e-05 8.155369491383e-01
+ 1.336700000000e-05 8.155979283535e-01
+ 1.336800000000e-05 8.156589075687e-01
+ 1.336900000000e-05 8.157198867839e-01
+ 1.337000000000e-05 8.157808659991e-01
+ 1.337100000000e-05 8.158418452143e-01
+ 1.337200000000e-05 8.159028244296e-01
+ 1.337300000000e-05 8.159638036448e-01
+ 1.337400000000e-05 8.160247828600e-01
+ 1.337500000000e-05 8.160857620752e-01
+ 1.337600000000e-05 8.161467412904e-01
+ 1.337700000000e-05 8.162077205056e-01
+ 1.337800000000e-05 8.162686997209e-01
+ 1.337900000000e-05 8.163296789361e-01
+ 1.338000000000e-05 8.163906581513e-01
+ 1.338100000000e-05 8.164516373665e-01
+ 1.338200000000e-05 8.165126165817e-01
+ 1.338300000000e-05 8.165735957969e-01
+ 1.338400000000e-05 8.166345750122e-01
+ 1.338500000000e-05 8.166955542274e-01
+ 1.338600000000e-05 8.167565334426e-01
+ 1.338700000000e-05 8.168175126578e-01
+ 1.338800000000e-05 8.168784918730e-01
+ 1.338900000000e-05 8.169394710882e-01
+ 1.339000000000e-05 8.170004503035e-01
+ 1.339100000000e-05 8.170614295187e-01
+ 1.339200000000e-05 8.171224087339e-01
+ 1.339300000000e-05 8.171833879491e-01
+ 1.339400000000e-05 8.172443671643e-01
+ 1.339500000000e-05 8.173053463795e-01
+ 1.339600000000e-05 8.173663255948e-01
+ 1.339700000000e-05 8.174273048100e-01
+ 1.339800000000e-05 8.174882840252e-01
+ 1.339900000000e-05 8.175492632404e-01
+ 1.340000000000e-05 8.176102424556e-01
+ 1.340100000000e-05 8.176712216708e-01
+ 1.340200000000e-05 8.177322008861e-01
+ 1.340300000000e-05 8.177931801013e-01
+ 1.340400000000e-05 8.178541593165e-01
+ 1.340500000000e-05 8.179151385317e-01
+ 1.340600000000e-05 8.179761177469e-01
+ 1.340700000000e-05 8.180370969621e-01
+ 1.340800000000e-05 8.180980761774e-01
+ 1.340900000000e-05 8.181590553926e-01
+ 1.341000000000e-05 8.182200346078e-01
+ 1.341100000000e-05 8.182810138230e-01
+ 1.341200000000e-05 8.183419930382e-01
+ 1.341300000000e-05 8.184029722534e-01
+ 1.341400000000e-05 8.184639514687e-01
+ 1.341500000000e-05 8.185249306839e-01
+ 1.341600000000e-05 8.185859098991e-01
+ 1.341700000000e-05 8.186468891143e-01
+ 1.341800000000e-05 8.187078683295e-01
+ 1.341900000000e-05 8.187688475447e-01
+ 1.342000000000e-05 8.188298267600e-01
+ 1.342100000000e-05 8.188908059752e-01
+ 1.342200000000e-05 8.189517851904e-01
+ 1.342300000000e-05 8.190127644056e-01
+ 1.342400000000e-05 8.190737436208e-01
+ 1.342500000000e-05 8.191347228360e-01
+ 1.342600000000e-05 8.191957020513e-01
+ 1.342700000000e-05 8.192566812665e-01
+ 1.342800000000e-05 8.193176604817e-01
+ 1.342900000000e-05 8.193786396969e-01
+ 1.343000000000e-05 8.194396189121e-01
+ 1.343100000000e-05 8.195005981273e-01
+ 1.343200000000e-05 8.195615773426e-01
+ 1.343300000000e-05 8.196225565578e-01
+ 1.343400000000e-05 8.196835357730e-01
+ 1.343500000000e-05 8.197445149882e-01
+ 1.343600000000e-05 8.198054942034e-01
+ 1.343700000000e-05 8.198664734186e-01
+ 1.343800000000e-05 8.199274526339e-01
+ 1.343900000000e-05 8.199884318491e-01
+ 1.344000000000e-05 8.200494110643e-01
+ 1.344100000000e-05 8.201103902795e-01
+ 1.344200000000e-05 8.201713694947e-01
+ 1.344300000000e-05 8.202323487099e-01
+ 1.344400000000e-05 8.202933279252e-01
+ 1.344500000000e-05 8.203543071404e-01
+ 1.344600000000e-05 8.204152863556e-01
+ 1.344700000000e-05 8.204762655708e-01
+ 1.344800000000e-05 8.205372447860e-01
+ 1.344900000000e-05 8.205982240012e-01
+ 1.345000000000e-05 8.206592032165e-01
+ 1.345100000000e-05 8.207201824317e-01
+ 1.345200000000e-05 8.207811616469e-01
+ 1.345300000000e-05 8.208421408621e-01
+ 1.345400000000e-05 8.209031200773e-01
+ 1.345500000000e-05 8.209640992925e-01
+ 1.345600000000e-05 8.210250785078e-01
+ 1.345700000000e-05 8.210860577230e-01
+ 1.345800000000e-05 8.211470369382e-01
+ 1.345900000000e-05 8.212080161534e-01
+ 1.346000000000e-05 8.212689953686e-01
+ 1.346100000000e-05 8.213299745838e-01
+ 1.346200000000e-05 8.213909537991e-01
+ 1.346300000000e-05 8.214519330143e-01
+ 1.346400000000e-05 8.215129122295e-01
+ 1.346500000000e-05 8.215738914447e-01
+ 1.346600000000e-05 8.216348706599e-01
+ 1.346700000000e-05 8.216958498751e-01
+ 1.346800000000e-05 8.217568290904e-01
+ 1.346900000000e-05 8.218178083056e-01
+ 1.347000000000e-05 8.218787875208e-01
+ 1.347100000000e-05 8.219397667360e-01
+ 1.347200000000e-05 8.220007459512e-01
+ 1.347300000000e-05 8.220617251664e-01
+ 1.347400000000e-05 8.221227043817e-01
+ 1.347500000000e-05 8.221836835969e-01
+ 1.347600000000e-05 8.222446628121e-01
+ 1.347700000000e-05 8.223056420273e-01
+ 1.347800000000e-05 8.223666212425e-01
+ 1.347900000000e-05 8.224276004577e-01
+ 1.348000000000e-05 8.224885796730e-01
+ 1.348100000000e-05 8.225495588882e-01
+ 1.348200000000e-05 8.226105381034e-01
+ 1.348300000000e-05 8.226715173186e-01
+ 1.348400000000e-05 8.227324965338e-01
+ 1.348500000000e-05 8.227934757490e-01
+ 1.348600000000e-05 8.228544549643e-01
+ 1.348700000000e-05 8.229154341795e-01
+ 1.348800000000e-05 8.229764133947e-01
+ 1.348900000000e-05 8.230373926099e-01
+ 1.349000000000e-05 8.230983718251e-01
+ 1.349100000000e-05 8.231593510403e-01
+ 1.349200000000e-05 8.232203302556e-01
+ 1.349300000000e-05 8.232813094708e-01
+ 1.349400000000e-05 8.233422886860e-01
+ 1.349500000000e-05 8.234032679012e-01
+ 1.349600000000e-05 8.234642471164e-01
+ 1.349700000000e-05 8.235252263316e-01
+ 1.349800000000e-05 8.235862055469e-01
+ 1.349900000000e-05 8.236471847621e-01
+ 1.350000000000e-05 8.237081639773e-01
+ 1.350100000000e-05 8.237691431925e-01
+ 1.350200000000e-05 8.238301224077e-01
+ 1.350300000000e-05 8.238911016229e-01
+ 1.350400000000e-05 8.239520808382e-01
+ 1.350500000000e-05 8.240130600534e-01
+ 1.350600000000e-05 8.240740392686e-01
+ 1.350700000000e-05 8.241350184838e-01
+ 1.350800000000e-05 8.241959976990e-01
+ 1.350900000000e-05 8.242569769142e-01
+ 1.351000000000e-05 8.243179561295e-01
+ 1.351100000000e-05 8.243789353447e-01
+ 1.351200000000e-05 8.244399145599e-01
+ 1.351300000000e-05 8.245008937751e-01
+ 1.351400000000e-05 8.245618729903e-01
+ 1.351500000000e-05 8.246228522055e-01
+ 1.351600000000e-05 8.246838314208e-01
+ 1.351700000000e-05 8.247448106360e-01
+ 1.351800000000e-05 8.248057898512e-01
+ 1.351900000000e-05 8.248667690664e-01
+ 1.352000000000e-05 8.249277482816e-01
+ 1.352100000000e-05 8.249887274968e-01
+ 1.352200000000e-05 8.250497067121e-01
+ 1.352300000000e-05 8.251106859273e-01
+ 1.352400000000e-05 8.251716651425e-01
+ 1.352500000000e-05 8.252326443577e-01
+ 1.352600000000e-05 8.252936235729e-01
+ 1.352700000000e-05 8.253546027881e-01
+ 1.352800000000e-05 8.254155820034e-01
+ 1.352900000000e-05 8.254765612186e-01
+ 1.353000000000e-05 8.255375404338e-01
+ 1.353100000000e-05 8.255985196490e-01
+ 1.353200000000e-05 8.256594988642e-01
+ 1.353300000000e-05 8.257204780794e-01
+ 1.353400000000e-05 8.257814572947e-01
+ 1.353500000000e-05 8.258424365099e-01
+ 1.353600000000e-05 8.259034157251e-01
+ 1.353700000000e-05 8.259643949403e-01
+ 1.353800000000e-05 8.260253741555e-01
+ 1.353900000000e-05 8.260863533707e-01
+ 1.354000000000e-05 8.261473325860e-01
+ 1.354100000000e-05 8.262083118012e-01
+ 1.354200000000e-05 8.262692910164e-01
+ 1.354300000000e-05 8.263302702316e-01
+ 1.354400000000e-05 8.263912494468e-01
+ 1.354500000000e-05 8.264522286620e-01
+ 1.354600000000e-05 8.265132078772e-01
+ 1.354700000000e-05 8.265741870925e-01
+ 1.354800000000e-05 8.266351663077e-01
+ 1.354900000000e-05 8.266961455229e-01
+ 1.355000000000e-05 8.267571247381e-01
+ 1.355100000000e-05 8.268181039533e-01
+ 1.355200000000e-05 8.268790831685e-01
+ 1.355300000000e-05 8.269400623838e-01
+ 1.355400000000e-05 8.270010415990e-01
+ 1.355500000000e-05 8.270620208142e-01
+ 1.355600000000e-05 8.271230000294e-01
+ 1.355700000000e-05 8.271839792446e-01
+ 1.355800000000e-05 8.272449584598e-01
+ 1.355900000000e-05 8.273059376751e-01
+ 1.356000000000e-05 8.273669168903e-01
+ 1.356100000000e-05 8.274278961055e-01
+ 1.356200000000e-05 8.274888753207e-01
+ 1.356300000000e-05 8.275498545359e-01
+ 1.356400000000e-05 8.276108337511e-01
+ 1.356500000000e-05 8.276718129664e-01
+ 1.356600000000e-05 8.277327921816e-01
+ 1.356700000000e-05 8.277937713968e-01
+ 1.356800000000e-05 8.278547506120e-01
+ 1.356900000000e-05 8.279157298272e-01
+ 1.357000000000e-05 8.279767090424e-01
+ 1.357100000000e-05 8.280376882577e-01
+ 1.357200000000e-05 8.280986674729e-01
+ 1.357300000000e-05 8.281596466881e-01
+ 1.357400000000e-05 8.282206259033e-01
+ 1.357500000000e-05 8.282816051185e-01
+ 1.357600000000e-05 8.283425843337e-01
+ 1.357700000000e-05 8.284035635490e-01
+ 1.357800000000e-05 8.284645427642e-01
+ 1.357900000000e-05 8.285255219794e-01
+ 1.358000000000e-05 8.285865011946e-01
+ 1.358100000000e-05 8.286474804098e-01
+ 1.358200000000e-05 8.287084596250e-01
+ 1.358300000000e-05 8.287694388403e-01
+ 1.358400000000e-05 8.288304180555e-01
+ 1.358500000000e-05 8.288913972707e-01
+ 1.358600000000e-05 8.289523764859e-01
+ 1.358700000000e-05 8.290133557011e-01
+ 1.358800000000e-05 8.290743349163e-01
+ 1.358900000000e-05 8.291353141316e-01
+ 1.359000000000e-05 8.291962933468e-01
+ 1.359100000000e-05 8.292572725620e-01
+ 1.359200000000e-05 8.293182517772e-01
+ 1.359300000000e-05 8.293792309924e-01
+ 1.359400000000e-05 8.294402102076e-01
+ 1.359500000000e-05 8.295011894229e-01
+ 1.359600000000e-05 8.295621686381e-01
+ 1.359700000000e-05 8.296231478533e-01
+ 1.359800000000e-05 8.296841270685e-01
+ 1.359900000000e-05 8.297451062837e-01
+ 1.360000000000e-05 8.298060854989e-01
+ 1.360100000000e-05 8.298670647142e-01
+ 1.360200000000e-05 8.299280439294e-01
+ 1.360300000000e-05 8.299890231446e-01
+ 1.360400000000e-05 8.300500023598e-01
+ 1.360500000000e-05 8.301109815750e-01
+ 1.360600000000e-05 8.301719607902e-01
+ 1.360700000000e-05 8.302329400055e-01
+ 1.360800000000e-05 8.302939192207e-01
+ 1.360900000000e-05 8.303548984359e-01
+ 1.361000000000e-05 8.304158776511e-01
+ 1.361100000000e-05 8.304768568663e-01
+ 1.361200000000e-05 8.305378360815e-01
+ 1.361300000000e-05 8.305988152968e-01
+ 1.361400000000e-05 8.306597945120e-01
+ 1.361500000000e-05 8.307207737272e-01
+ 1.361600000000e-05 8.307817529424e-01
+ 1.361700000000e-05 8.308427321576e-01
+ 1.361800000000e-05 8.309037113728e-01
+ 1.361900000000e-05 8.309646905881e-01
+ 1.362000000000e-05 8.310256698033e-01
+ 1.362100000000e-05 8.310866490185e-01
+ 1.362200000000e-05 8.311476282337e-01
+ 1.362300000000e-05 8.312086074489e-01
+ 1.362400000000e-05 8.312695866641e-01
+ 1.362500000000e-05 8.313305658794e-01
+ 1.362600000000e-05 8.313915450946e-01
+ 1.362700000000e-05 8.314525243098e-01
+ 1.362800000000e-05 8.315135035250e-01
+ 1.362900000000e-05 8.315744827402e-01
+ 1.363000000000e-05 8.316354619554e-01
+ 1.363100000000e-05 8.316964411707e-01
+ 1.363200000000e-05 8.317574203859e-01
+ 1.363300000000e-05 8.318183996011e-01
+ 1.363400000000e-05 8.318793788163e-01
+ 1.363500000000e-05 8.319403580315e-01
+ 1.363600000000e-05 8.320013372467e-01
+ 1.363700000000e-05 8.320623164620e-01
+ 1.363800000000e-05 8.321232956772e-01
+ 1.363900000000e-05 8.321842748924e-01
+ 1.364000000000e-05 8.322452541076e-01
+ 1.364100000000e-05 8.323062333228e-01
+ 1.364200000000e-05 8.323672125380e-01
+ 1.364300000000e-05 8.324281917533e-01
+ 1.364400000000e-05 8.324891709685e-01
+ 1.364500000000e-05 8.325501501837e-01
+ 1.364600000000e-05 8.326111293989e-01
+ 1.364700000000e-05 8.326721086141e-01
+ 1.364800000000e-05 8.327330878293e-01
+ 1.364900000000e-05 8.327940670446e-01
+ 1.365000000000e-05 8.328550462598e-01
+ 1.365100000000e-05 8.329160254750e-01
+ 1.365200000000e-05 8.329770046902e-01
+ 1.365300000000e-05 8.330379839054e-01
+ 1.365400000000e-05 8.330989631206e-01
+ 1.365500000000e-05 8.331599423359e-01
+ 1.365600000000e-05 8.332209215511e-01
+ 1.365700000000e-05 8.332819007663e-01
+ 1.365800000000e-05 8.333428799815e-01
+ 1.365900000000e-05 8.334038591967e-01
+ 1.366000000000e-05 8.334648384119e-01
+ 1.366100000000e-05 8.335258176272e-01
+ 1.366200000000e-05 8.335867968424e-01
+ 1.366300000000e-05 8.336477760576e-01
+ 1.366400000000e-05 8.337087552728e-01
+ 1.366500000000e-05 8.337697344880e-01
+ 1.366600000000e-05 8.338307137032e-01
+ 1.366700000000e-05 8.338916929185e-01
+ 1.366800000000e-05 8.339526721337e-01
+ 1.366900000000e-05 8.340136513489e-01
+ 1.367000000000e-05 8.340746305641e-01
+ 1.367100000000e-05 8.341356097793e-01
+ 1.367200000000e-05 8.341965889945e-01
+ 1.367300000000e-05 8.342575682098e-01
+ 1.367400000000e-05 8.343185474250e-01
+ 1.367500000000e-05 8.343795266402e-01
+ 1.367600000000e-05 8.344405058554e-01
+ 1.367700000000e-05 8.345014850706e-01
+ 1.367800000000e-05 8.345624642858e-01
+ 1.367900000000e-05 8.346234435011e-01
+ 1.368000000000e-05 8.346844227163e-01
+ 1.368100000000e-05 8.347454019315e-01
+ 1.368200000000e-05 8.348063811467e-01
+ 1.368300000000e-05 8.348673603619e-01
+ 1.368400000000e-05 8.349283395771e-01
+ 1.368500000000e-05 8.349893187924e-01
+ 1.368600000000e-05 8.350502980076e-01
+ 1.368700000000e-05 8.351112772228e-01
+ 1.368800000000e-05 8.351722564380e-01
+ 1.368900000000e-05 8.352332356532e-01
+ 1.369000000000e-05 8.352942148684e-01
+ 1.369100000000e-05 8.353551940837e-01
+ 1.369200000000e-05 8.354161732989e-01
+ 1.369300000000e-05 8.354771525141e-01
+ 1.369400000000e-05 8.355381317293e-01
+ 1.369500000000e-05 8.355991109445e-01
+ 1.369600000000e-05 8.356600901597e-01
+ 1.369700000000e-05 8.357210693750e-01
+ 1.369800000000e-05 8.357820485902e-01
+ 1.369900000000e-05 8.358430278054e-01
+ 1.370000000000e-05 8.359040070206e-01
+ 1.370100000000e-05 8.359649862358e-01
+ 1.370200000000e-05 8.360259654510e-01
+ 1.370300000000e-05 8.360869446663e-01
+ 1.370400000000e-05 8.361479238815e-01
+ 1.370500000000e-05 8.362089030967e-01
+ 1.370600000000e-05 8.362698823119e-01
+ 1.370700000000e-05 8.363308615271e-01
+ 1.370800000000e-05 8.363918407423e-01
+ 1.370900000000e-05 8.364528199576e-01
+ 1.371000000000e-05 8.365137991728e-01
+ 1.371100000000e-05 8.365747783880e-01
+ 1.371200000000e-05 8.366357576032e-01
+ 1.371300000000e-05 8.366967368184e-01
+ 1.371400000000e-05 8.367577160336e-01
+ 1.371500000000e-05 8.368186952489e-01
+ 1.371600000000e-05 8.368796744641e-01
+ 1.371700000000e-05 8.369406536793e-01
+ 1.371800000000e-05 8.370016328945e-01
+ 1.371900000000e-05 8.370626121097e-01
+ 1.372000000000e-05 8.371235913249e-01
+ 1.372100000000e-05 8.371845705402e-01
+ 1.372200000000e-05 8.372455497554e-01
+ 1.372300000000e-05 8.373065289706e-01
+ 1.372400000000e-05 8.373675081858e-01
+ 1.372500000000e-05 8.374284874010e-01
+ 1.372600000000e-05 8.374894666162e-01
+ 1.372700000000e-05 8.375504458315e-01
+ 1.372800000000e-05 8.376114250467e-01
+ 1.372900000000e-05 8.376724042619e-01
+ 1.373000000000e-05 8.377333834771e-01
+ 1.373100000000e-05 8.377943626923e-01
+ 1.373200000000e-05 8.378553419075e-01
+ 1.373300000000e-05 8.379163211228e-01
+ 1.373400000000e-05 8.379773003380e-01
+ 1.373500000000e-05 8.380382795532e-01
+ 1.373600000000e-05 8.380992587684e-01
+ 1.373700000000e-05 8.381602379836e-01
+ 1.373800000000e-05 8.382212171988e-01
+ 1.373900000000e-05 8.382821964141e-01
+ 1.374000000000e-05 8.383431756293e-01
+ 1.374100000000e-05 8.384041548445e-01
+ 1.374200000000e-05 8.384651340597e-01
+ 1.374300000000e-05 8.385261132749e-01
+ 1.374400000000e-05 8.385870924901e-01
+ 1.374500000000e-05 8.386480717054e-01
+ 1.374600000000e-05 8.387090509206e-01
+ 1.374700000000e-05 8.387700301358e-01
+ 1.374800000000e-05 8.388310093510e-01
+ 1.374900000000e-05 8.388919885662e-01
+ 1.375000000000e-05 8.389529677814e-01
+ 1.375100000000e-05 8.390139469967e-01
+ 1.375200000000e-05 8.390749262119e-01
+ 1.375300000000e-05 8.391359054271e-01
+ 1.375400000000e-05 8.391968846423e-01
+ 1.375500000000e-05 8.392578638575e-01
+ 1.375600000000e-05 8.393188430727e-01
+ 1.375700000000e-05 8.393798222880e-01
+ 1.375800000000e-05 8.394408015032e-01
+ 1.375900000000e-05 8.395017807184e-01
+ 1.376000000000e-05 8.395627599336e-01
+ 1.376100000000e-05 8.396237391488e-01
+ 1.376200000000e-05 8.396847183640e-01
+ 1.376300000000e-05 8.397456975793e-01
+ 1.376400000000e-05 8.398066767945e-01
+ 1.376500000000e-05 8.398676560097e-01
+ 1.376600000000e-05 8.399286352249e-01
+ 1.376700000000e-05 8.399896144401e-01
+ 1.376800000000e-05 8.400505936553e-01
+ 1.376900000000e-05 8.401115728706e-01
+ 1.377000000000e-05 8.401725520858e-01
+ 1.377100000000e-05 8.402335313010e-01
+ 1.377200000000e-05 8.402945105162e-01
+ 1.377300000000e-05 8.403554897314e-01
+ 1.377400000000e-05 8.404164689466e-01
+ 1.377500000000e-05 8.404774481618e-01
+ 1.377600000000e-05 8.405384273771e-01
+ 1.377700000000e-05 8.405994065923e-01
+ 1.377800000000e-05 8.406603858075e-01
+ 1.377900000000e-05 8.407213650227e-01
+ 1.378000000000e-05 8.407823442379e-01
+ 1.378100000000e-05 8.408433234531e-01
+ 1.378200000000e-05 8.409043026684e-01
+ 1.378300000000e-05 8.409652818836e-01
+ 1.378400000000e-05 8.410262610988e-01
+ 1.378500000000e-05 8.410872403140e-01
+ 1.378600000000e-05 8.411482195292e-01
+ 1.378700000000e-05 8.412091987444e-01
+ 1.378800000000e-05 8.412701779597e-01
+ 1.378900000000e-05 8.413311571749e-01
+ 1.379000000000e-05 8.413921363901e-01
+ 1.379100000000e-05 8.414531156053e-01
+ 1.379200000000e-05 8.415140948205e-01
+ 1.379300000000e-05 8.415750740357e-01
+ 1.379400000000e-05 8.416360532510e-01
+ 1.379500000000e-05 8.416970324662e-01
+ 1.379600000000e-05 8.417580116814e-01
+ 1.379700000000e-05 8.418189908966e-01
+ 1.379800000000e-05 8.418799701118e-01
+ 1.379900000000e-05 8.419409493270e-01
+ 1.380000000000e-05 8.420019285423e-01
+ 1.380100000000e-05 8.420629077575e-01
+ 1.380200000000e-05 8.421238869727e-01
+ 1.380300000000e-05 8.421848661879e-01
+ 1.380400000000e-05 8.422458454031e-01
+ 1.380500000000e-05 8.423068246183e-01
+ 1.380600000000e-05 8.423678038336e-01
+ 1.380700000000e-05 8.424287830488e-01
+ 1.380800000000e-05 8.424897622640e-01
+ 1.380900000000e-05 8.425507414792e-01
+ 1.381000000000e-05 8.426117206944e-01
+ 1.381100000000e-05 8.426726999096e-01
+ 1.381200000000e-05 8.427336791249e-01
+ 1.381300000000e-05 8.427946583401e-01
+ 1.381400000000e-05 8.428556375553e-01
+ 1.381500000000e-05 8.429166167705e-01
+ 1.381600000000e-05 8.429775959857e-01
+ 1.381700000000e-05 8.430385752009e-01
+ 1.381800000000e-05 8.430995544162e-01
+ 1.381900000000e-05 8.431605336314e-01
+ 1.382000000000e-05 8.432215128466e-01
+ 1.382100000000e-05 8.432824920618e-01
+ 1.382200000000e-05 8.433434712770e-01
+ 1.382300000000e-05 8.434044504922e-01
+ 1.382400000000e-05 8.434654297075e-01
+ 1.382500000000e-05 8.435264089227e-01
+ 1.382600000000e-05 8.435873881379e-01
+ 1.382700000000e-05 8.436483673531e-01
+ 1.382800000000e-05 8.437093465683e-01
+ 1.382900000000e-05 8.437703257835e-01
+ 1.383000000000e-05 8.438313049988e-01
+ 1.383100000000e-05 8.438922842140e-01
+ 1.383200000000e-05 8.439532634292e-01
+ 1.383300000000e-05 8.440142426444e-01
+ 1.383400000000e-05 8.440752218596e-01
+ 1.383500000000e-05 8.441362010748e-01
+ 1.383600000000e-05 8.441971802901e-01
+ 1.383700000000e-05 8.442581595053e-01
+ 1.383800000000e-05 8.443191387205e-01
+ 1.383900000000e-05 8.443801179357e-01
+ 1.384000000000e-05 8.444410971509e-01
+ 1.384100000000e-05 8.445020763661e-01
+ 1.384200000000e-05 8.445630555814e-01
+ 1.384300000000e-05 8.446240347966e-01
+ 1.384400000000e-05 8.446850140118e-01
+ 1.384500000000e-05 8.447459932270e-01
+ 1.384600000000e-05 8.448069724422e-01
+ 1.384700000000e-05 8.448679516574e-01
+ 1.384800000000e-05 8.449289308727e-01
+ 1.384900000000e-05 8.449899100879e-01
+ 1.385000000000e-05 8.450508893031e-01
+ 1.385100000000e-05 8.451118685183e-01
+ 1.385200000000e-05 8.451728477335e-01
+ 1.385300000000e-05 8.452338269487e-01
+ 1.385400000000e-05 8.452948061640e-01
+ 1.385500000000e-05 8.453557853792e-01
+ 1.385600000000e-05 8.454167645944e-01
+ 1.385700000000e-05 8.454777438096e-01
+ 1.385800000000e-05 8.455387230248e-01
+ 1.385900000000e-05 8.455997022400e-01
+ 1.386000000000e-05 8.456606814553e-01
+ 1.386100000000e-05 8.457216606705e-01
+ 1.386200000000e-05 8.457826398857e-01
+ 1.386300000000e-05 8.458436191009e-01
+ 1.386400000000e-05 8.459045983161e-01
+ 1.386500000000e-05 8.459655775313e-01
+ 1.386600000000e-05 8.460265567466e-01
+ 1.386700000000e-05 8.460875359618e-01
+ 1.386800000000e-05 8.461485151770e-01
+ 1.386900000000e-05 8.462094943922e-01
+ 1.387000000000e-05 8.462704736074e-01
+ 1.387100000000e-05 8.463314528226e-01
+ 1.387200000000e-05 8.463924320379e-01
+ 1.387300000000e-05 8.464534112531e-01
+ 1.387400000000e-05 8.465143904683e-01
+ 1.387500000000e-05 8.465753696835e-01
+ 1.387600000000e-05 8.466363488987e-01
+ 1.387700000000e-05 8.466973281139e-01
+ 1.387800000000e-05 8.467583073292e-01
+ 1.387900000000e-05 8.468192865444e-01
+ 1.388000000000e-05 8.468802657596e-01
+ 1.388100000000e-05 8.469412449748e-01
+ 1.388200000000e-05 8.470022241900e-01
+ 1.388300000000e-05 8.470632034052e-01
+ 1.388400000000e-05 8.471241826205e-01
+ 1.388500000000e-05 8.471851618357e-01
+ 1.388600000000e-05 8.472461410509e-01
+ 1.388700000000e-05 8.473071202661e-01
+ 1.388800000000e-05 8.473680994813e-01
+ 1.388900000000e-05 8.474290786965e-01
+ 1.389000000000e-05 8.474900579118e-01
+ 1.389100000000e-05 8.475510371270e-01
+ 1.389200000000e-05 8.476120163422e-01
+ 1.389300000000e-05 8.476729955574e-01
+ 1.389400000000e-05 8.477339747726e-01
+ 1.389500000000e-05 8.477949539878e-01
+ 1.389600000000e-05 8.478559332031e-01
+ 1.389700000000e-05 8.479169124183e-01
+ 1.389800000000e-05 8.479778916335e-01
+ 1.389900000000e-05 8.480388708487e-01
+ 1.390000000000e-05 8.480998500639e-01
+ 1.390100000000e-05 8.481608292791e-01
+ 1.390200000000e-05 8.482218084944e-01
+ 1.390300000000e-05 8.482827877096e-01
+ 1.390400000000e-05 8.483437669248e-01
+ 1.390500000000e-05 8.484047461400e-01
+ 1.390600000000e-05 8.484657253552e-01
+ 1.390700000000e-05 8.485267045704e-01
+ 1.390800000000e-05 8.485876837857e-01
+ 1.390900000000e-05 8.486486630009e-01
+ 1.391000000000e-05 8.487096422161e-01
+ 1.391100000000e-05 8.487706214313e-01
+ 1.391200000000e-05 8.488316006465e-01
+ 1.391300000000e-05 8.488925798617e-01
+ 1.391400000000e-05 8.489535590770e-01
+ 1.391500000000e-05 8.490145382922e-01
+ 1.391600000000e-05 8.490755175074e-01
+ 1.391700000000e-05 8.491364967226e-01
+ 1.391800000000e-05 8.491974759378e-01
+ 1.391900000000e-05 8.492584551530e-01
+ 1.392000000000e-05 8.493194343683e-01
+ 1.392100000000e-05 8.493804135835e-01
+ 1.392200000000e-05 8.494413927987e-01
+ 1.392300000000e-05 8.495023720139e-01
+ 1.392400000000e-05 8.495633512291e-01
+ 1.392500000000e-05 8.496243304443e-01
+ 1.392600000000e-05 8.496853096596e-01
+ 1.392700000000e-05 8.497462888748e-01
+ 1.392800000000e-05 8.498072680900e-01
+ 1.392900000000e-05 8.498682473052e-01
+ 1.393000000000e-05 8.499292265204e-01
+ 1.393100000000e-05 8.499902057356e-01
+ 1.393200000000e-05 8.500511849509e-01
+ 1.393300000000e-05 8.501121641661e-01
+ 1.393400000000e-05 8.501731433813e-01
+ 1.393500000000e-05 8.502341225965e-01
+ 1.393600000000e-05 8.502951018117e-01
+ 1.393700000000e-05 8.503560810269e-01
+ 1.393800000000e-05 8.504170602422e-01
+ 1.393900000000e-05 8.504780394574e-01
+ 1.394000000000e-05 8.505390186726e-01
+ 1.394100000000e-05 8.505999978878e-01
+ 1.394200000000e-05 8.506609771030e-01
+ 1.394300000000e-05 8.507219563182e-01
+ 1.394400000000e-05 8.507829355335e-01
+ 1.394500000000e-05 8.508439147487e-01
+ 1.394600000000e-05 8.509048939639e-01
+ 1.394700000000e-05 8.509658731791e-01
+ 1.394800000000e-05 8.510268523943e-01
+ 1.394900000000e-05 8.510878316095e-01
+ 1.395000000000e-05 8.511488108248e-01
+ 1.395100000000e-05 8.512097900400e-01
+ 1.395200000000e-05 8.512707692552e-01
+ 1.395300000000e-05 8.513317484704e-01
+ 1.395400000000e-05 8.513927276856e-01
+ 1.395500000000e-05 8.514537069008e-01
+ 1.395600000000e-05 8.515146861161e-01
+ 1.395700000000e-05 8.515756653313e-01
+ 1.395800000000e-05 8.516366445465e-01
+ 1.395900000000e-05 8.516976237617e-01
+ 1.396000000000e-05 8.517586029769e-01
+ 1.396100000000e-05 8.518195821921e-01
+ 1.396200000000e-05 8.518805614074e-01
+ 1.396300000000e-05 8.519415406226e-01
+ 1.396400000000e-05 8.520025198378e-01
+ 1.396500000000e-05 8.520634990530e-01
+ 1.396600000000e-05 8.521244782682e-01
+ 1.396700000000e-05 8.521854574834e-01
+ 1.396800000000e-05 8.522464366987e-01
+ 1.396900000000e-05 8.523074159139e-01
+ 1.397000000000e-05 8.523683951291e-01
+ 1.397100000000e-05 8.524293743443e-01
+ 1.397200000000e-05 8.524903535595e-01
+ 1.397300000000e-05 8.525513327747e-01
+ 1.397400000000e-05 8.526123119900e-01
+ 1.397500000000e-05 8.526732912052e-01
+ 1.397600000000e-05 8.527342704204e-01
+ 1.397700000000e-05 8.527952496356e-01
+ 1.397800000000e-05 8.528562288508e-01
+ 1.397900000000e-05 8.529172080660e-01
+ 1.398000000000e-05 8.529781872813e-01
+ 1.398100000000e-05 8.530391664965e-01
+ 1.398200000000e-05 8.531001457117e-01
+ 1.398300000000e-05 8.531611249269e-01
+ 1.398400000000e-05 8.532221041421e-01
+ 1.398500000000e-05 8.532830833573e-01
+ 1.398600000000e-05 8.533440625726e-01
+ 1.398700000000e-05 8.534050417878e-01
+ 1.398800000000e-05 8.534660210030e-01
+ 1.398900000000e-05 8.535270002182e-01
+ 1.399000000000e-05 8.535879794334e-01
+ 1.399100000000e-05 8.536489586486e-01
+ 1.399200000000e-05 8.537099378639e-01
+ 1.399300000000e-05 8.537709170791e-01
+ 1.399400000000e-05 8.538318962943e-01
+ 1.399500000000e-05 8.538928755095e-01
+ 1.399600000000e-05 8.539538547247e-01
+ 1.399700000000e-05 8.540148339399e-01
+ 1.399800000000e-05 8.540758131551e-01
+ 1.399900000000e-05 8.541367923704e-01
+ 1.400000000000e-05 8.541977715856e-01
+ 1.400100000000e-05 8.542587508008e-01
+ 1.400200000000e-05 8.543197300160e-01
+ 1.400300000000e-05 8.543807092312e-01
+ 1.400400000000e-05 8.544416884464e-01
+ 1.400500000000e-05 8.545026676617e-01
+ 1.400600000000e-05 8.545636468769e-01
+ 1.400700000000e-05 8.546246260921e-01
+ 1.400800000000e-05 8.546856053073e-01
+ 1.400900000000e-05 8.547465845225e-01
+ 1.401000000000e-05 8.548075637377e-01
+ 1.401100000000e-05 8.548685429530e-01
+ 1.401200000000e-05 8.549295221682e-01
+ 1.401300000000e-05 8.549905013834e-01
+ 1.401400000000e-05 8.550514805986e-01
+ 1.401500000000e-05 8.551124598138e-01
+ 1.401600000000e-05 8.551734390290e-01
+ 1.401700000000e-05 8.552344182443e-01
+ 1.401800000000e-05 8.552953974595e-01
+ 1.401900000000e-05 8.553563766747e-01
+ 1.402000000000e-05 8.554173558899e-01
+ 1.402100000000e-05 8.554783351051e-01
+ 1.402200000000e-05 8.555393143203e-01
+ 1.402300000000e-05 8.556002935356e-01
+ 1.402400000000e-05 8.556612727508e-01
+ 1.402500000000e-05 8.557222519660e-01
+ 1.402600000000e-05 8.557832311812e-01
+ 1.402700000000e-05 8.558442103964e-01
+ 1.402800000000e-05 8.559051896116e-01
+ 1.402900000000e-05 8.559661688269e-01
+ 1.403000000000e-05 8.560271480421e-01
+ 1.403100000000e-05 8.560881272573e-01
+ 1.403200000000e-05 8.561491064725e-01
+ 1.403300000000e-05 8.562100856877e-01
+ 1.403400000000e-05 8.562710649029e-01
+ 1.403500000000e-05 8.563320441182e-01
+ 1.403600000000e-05 8.563930233334e-01
+ 1.403700000000e-05 8.564540025486e-01
+ 1.403800000000e-05 8.565149817638e-01
+ 1.403900000000e-05 8.565759609790e-01
+ 1.404000000000e-05 8.566369401942e-01
+ 1.404100000000e-05 8.566979194095e-01
+ 1.404200000000e-05 8.567588986247e-01
+ 1.404300000000e-05 8.568198778399e-01
+ 1.404400000000e-05 8.568808570551e-01
+ 1.404500000000e-05 8.569418362703e-01
+ 1.404600000000e-05 8.570028154855e-01
+ 1.404700000000e-05 8.570637947008e-01
+ 1.404800000000e-05 8.571247739160e-01
+ 1.404900000000e-05 8.571857531312e-01
+ 1.405000000000e-05 8.572467323464e-01
+ 1.405100000000e-05 8.573077115616e-01
+ 1.405200000000e-05 8.573686907768e-01
+ 1.405300000000e-05 8.574296699921e-01
+ 1.405400000000e-05 8.574906492073e-01
+ 1.405500000000e-05 8.575516284225e-01
+ 1.405600000000e-05 8.576126076377e-01
+ 1.405700000000e-05 8.576735868529e-01
+ 1.405800000000e-05 8.577345660681e-01
+ 1.405900000000e-05 8.577955452834e-01
+ 1.406000000000e-05 8.578565244986e-01
+ 1.406100000000e-05 8.579175037138e-01
+ 1.406200000000e-05 8.579784829290e-01
+ 1.406300000000e-05 8.580394621442e-01
+ 1.406400000000e-05 8.581004413594e-01
+ 1.406500000000e-05 8.581614205747e-01
+ 1.406600000000e-05 8.582223997899e-01
+ 1.406700000000e-05 8.582833790051e-01
+ 1.406800000000e-05 8.583443582203e-01
+ 1.406900000000e-05 8.584053374355e-01
+ 1.407000000000e-05 8.584663166507e-01
+ 1.407100000000e-05 8.585272958660e-01
+ 1.407200000000e-05 8.585882750812e-01
+ 1.407300000000e-05 8.586492542964e-01
+ 1.407400000000e-05 8.587102335116e-01
+ 1.407500000000e-05 8.587712127268e-01
+ 1.407600000000e-05 8.588321919420e-01
+ 1.407700000000e-05 8.588931711573e-01
+ 1.407800000000e-05 8.589541503725e-01
+ 1.407900000000e-05 8.590151295877e-01
+ 1.408000000000e-05 8.590761088029e-01
+ 1.408100000000e-05 8.591370880181e-01
+ 1.408200000000e-05 8.591980672333e-01
+ 1.408300000000e-05 8.592590464486e-01
+ 1.408400000000e-05 8.593200256638e-01
+ 1.408500000000e-05 8.593810048790e-01
+ 1.408600000000e-05 8.594419840942e-01
+ 1.408700000000e-05 8.595029633094e-01
+ 1.408800000000e-05 8.595639425246e-01
+ 1.408900000000e-05 8.596249217399e-01
+ 1.409000000000e-05 8.596859009551e-01
+ 1.409100000000e-05 8.597468801703e-01
+ 1.409200000000e-05 8.598078593855e-01
+ 1.409300000000e-05 8.598688386007e-01
+ 1.409400000000e-05 8.599298178159e-01
+ 1.409500000000e-05 8.599907970312e-01
+ 1.409600000000e-05 8.600517762464e-01
+ 1.409700000000e-05 8.601127554616e-01
+ 1.409800000000e-05 8.601737346768e-01
+ 1.409900000000e-05 8.602347138920e-01
+ 1.410000000000e-05 8.602956931072e-01
+ 1.410100000000e-05 8.603566723225e-01
+ 1.410200000000e-05 8.604176515377e-01
+ 1.410300000000e-05 8.604786307529e-01
+ 1.410400000000e-05 8.605396099681e-01
+ 1.410500000000e-05 8.606005891833e-01
+ 1.410600000000e-05 8.606615683985e-01
+ 1.410700000000e-05 8.607225476138e-01
+ 1.410800000000e-05 8.607835268290e-01
+ 1.410900000000e-05 8.608445060442e-01
+ 1.411000000000e-05 8.609054852594e-01
+ 1.411100000000e-05 8.609664644746e-01
+ 1.411200000000e-05 8.610274436898e-01
+ 1.411300000000e-05 8.610884229051e-01
+ 1.411400000000e-05 8.611494021203e-01
+ 1.411500000000e-05 8.612103813355e-01
+ 1.411600000000e-05 8.612713605507e-01
+ 1.411700000000e-05 8.613323397659e-01
+ 1.411800000000e-05 8.613933189811e-01
+ 1.411900000000e-05 8.614542981964e-01
+ 1.412000000000e-05 8.615152774116e-01
+ 1.412100000000e-05 8.615762566268e-01
+ 1.412200000000e-05 8.616372358420e-01
+ 1.412300000000e-05 8.616982150572e-01
+ 1.412400000000e-05 8.617591942724e-01
+ 1.412500000000e-05 8.618201734877e-01
+ 1.412600000000e-05 8.618811527029e-01
+ 1.412700000000e-05 8.619421319181e-01
+ 1.412800000000e-05 8.620031111333e-01
+ 1.412900000000e-05 8.620640903485e-01
+ 1.413000000000e-05 8.621250695637e-01
+ 1.413100000000e-05 8.621860487790e-01
+ 1.413200000000e-05 8.622470279942e-01
+ 1.413300000000e-05 8.623080072094e-01
+ 1.413400000000e-05 8.623689864246e-01
+ 1.413500000000e-05 8.624299656398e-01
+ 1.413600000000e-05 8.624909448550e-01
+ 1.413700000000e-05 8.625519240703e-01
+ 1.413800000000e-05 8.626129032855e-01
+ 1.413900000000e-05 8.626738825007e-01
+ 1.414000000000e-05 8.627348617159e-01
+ 1.414100000000e-05 8.627958409311e-01
+ 1.414200000000e-05 8.628568201463e-01
+ 1.414300000000e-05 8.629177993616e-01
+ 1.414400000000e-05 8.629787785768e-01
+ 1.414500000000e-05 8.630397577920e-01
+ 1.414600000000e-05 8.631007370072e-01
+ 1.414700000000e-05 8.631617162224e-01
+ 1.414800000000e-05 8.632226954376e-01
+ 1.414900000000e-05 8.632836746529e-01
+ 1.415000000000e-05 8.633446538681e-01
+ 1.415100000000e-05 8.634056330833e-01
+ 1.415200000000e-05 8.634666122985e-01
+ 1.415300000000e-05 8.635275915137e-01
+ 1.415400000000e-05 8.635885707289e-01
+ 1.415500000000e-05 8.636495499442e-01
+ 1.415600000000e-05 8.637105291594e-01
+ 1.415700000000e-05 8.637715083746e-01
+ 1.415800000000e-05 8.638324875898e-01
+ 1.415900000000e-05 8.638934668050e-01
+ 1.416000000000e-05 8.639544460202e-01
+ 1.416100000000e-05 8.640154252355e-01
+ 1.416200000000e-05 8.640764044507e-01
+ 1.416300000000e-05 8.641373836659e-01
+ 1.416400000000e-05 8.641983628811e-01
+ 1.416500000000e-05 8.642593420963e-01
+ 1.416600000000e-05 8.643203213115e-01
+ 1.416700000000e-05 8.643813005268e-01
+ 1.416800000000e-05 8.644422797420e-01
+ 1.416900000000e-05 8.645032589572e-01
+ 1.417000000000e-05 8.645642381724e-01
+ 1.417100000000e-05 8.646252173876e-01
+ 1.417200000000e-05 8.646861966028e-01
+ 1.417300000000e-05 8.647471758181e-01
+ 1.417400000000e-05 8.648081550333e-01
+ 1.417500000000e-05 8.648691342485e-01
+ 1.417600000000e-05 8.649301134637e-01
+ 1.417700000000e-05 8.649910926789e-01
+ 1.417800000000e-05 8.650520718941e-01
+ 1.417900000000e-05 8.651130511094e-01
+ 1.418000000000e-05 8.651740303246e-01
+ 1.418100000000e-05 8.652350095398e-01
+ 1.418200000000e-05 8.652959887550e-01
+ 1.418300000000e-05 8.653569679702e-01
+ 1.418400000000e-05 8.654179471854e-01
+ 1.418500000000e-05 8.654789264007e-01
+ 1.418600000000e-05 8.655399056159e-01
+ 1.418700000000e-05 8.656008848311e-01
+ 1.418800000000e-05 8.656618640463e-01
+ 1.418900000000e-05 8.657228432615e-01
+ 1.419000000000e-05 8.657838224767e-01
+ 1.419100000000e-05 8.658448016920e-01
+ 1.419200000000e-05 8.659057809072e-01
+ 1.419300000000e-05 8.659667601224e-01
+ 1.419400000000e-05 8.660277393376e-01
+ 1.419500000000e-05 8.660887185528e-01
+ 1.419600000000e-05 8.661496977680e-01
+ 1.419700000000e-05 8.662106769833e-01
+ 1.419800000000e-05 8.662716561985e-01
+ 1.419900000000e-05 8.663326354137e-01
+ 1.420000000000e-05 8.663936146289e-01
+ 1.420100000000e-05 8.664545938441e-01
+ 1.420200000000e-05 8.665155730593e-01
+ 1.420300000000e-05 8.665765522746e-01
+ 1.420400000000e-05 8.666375314898e-01
+ 1.420500000000e-05 8.666985107050e-01
+ 1.420600000000e-05 8.667594899202e-01
+ 1.420700000000e-05 8.668204691354e-01
+ 1.420800000000e-05 8.668814483506e-01
+ 1.420900000000e-05 8.669424275659e-01
+ 1.421000000000e-05 8.670034067811e-01
+ 1.421100000000e-05 8.670643859963e-01
+ 1.421200000000e-05 8.671253652115e-01
+ 1.421300000000e-05 8.671863444267e-01
+ 1.421400000000e-05 8.672473236419e-01
+ 1.421500000000e-05 8.673083028572e-01
+ 1.421600000000e-05 8.673692820724e-01
+ 1.421700000000e-05 8.674302612876e-01
+ 1.421800000000e-05 8.674912405028e-01
+ 1.421900000000e-05 8.675522197180e-01
+ 1.422000000000e-05 8.676131989332e-01
+ 1.422100000000e-05 8.676741781485e-01
+ 1.422200000000e-05 8.677351573637e-01
+ 1.422300000000e-05 8.677961365789e-01
+ 1.422400000000e-05 8.678571157941e-01
+ 1.422500000000e-05 8.679180950093e-01
+ 1.422600000000e-05 8.679790742245e-01
+ 1.422700000000e-05 8.680400534397e-01
+ 1.422800000000e-05 8.681010326550e-01
+ 1.422900000000e-05 8.681620118702e-01
+ 1.423000000000e-05 8.682229910854e-01
+ 1.423100000000e-05 8.682839703006e-01
+ 1.423200000000e-05 8.683449495158e-01
+ 1.423300000000e-05 8.684059287310e-01
+ 1.423400000000e-05 8.684669079463e-01
+ 1.423500000000e-05 8.685278871615e-01
+ 1.423600000000e-05 8.685888663767e-01
+ 1.423700000000e-05 8.686498455919e-01
+ 1.423800000000e-05 8.687108248071e-01
+ 1.423900000000e-05 8.687718040223e-01
+ 1.424000000000e-05 8.688327832376e-01
+ 1.424100000000e-05 8.688937624528e-01
+ 1.424200000000e-05 8.689547416680e-01
+ 1.424300000000e-05 8.690157208832e-01
+ 1.424400000000e-05 8.690767000984e-01
+ 1.424500000000e-05 8.691376793136e-01
+ 1.424600000000e-05 8.691986585289e-01
+ 1.424700000000e-05 8.692596377441e-01
+ 1.424800000000e-05 8.693206169593e-01
+ 1.424900000000e-05 8.693815961745e-01
+ 1.425000000000e-05 8.694425753897e-01
+ 1.425100000000e-05 8.695035546049e-01
+ 1.425200000000e-05 8.695645338202e-01
+ 1.425300000000e-05 8.696255130354e-01
+ 1.425400000000e-05 8.696864922506e-01
+ 1.425500000000e-05 8.697474714658e-01
+ 1.425600000000e-05 8.698084506810e-01
+ 1.425700000000e-05 8.698694298962e-01
+ 1.425800000000e-05 8.699304091115e-01
+ 1.425900000000e-05 8.699913883267e-01
+ 1.426000000000e-05 8.700523675419e-01
+ 1.426100000000e-05 8.701133467571e-01
+ 1.426200000000e-05 8.701743259723e-01
+ 1.426300000000e-05 8.702353051875e-01
+ 1.426400000000e-05 8.702962844028e-01
+ 1.426500000000e-05 8.703572636180e-01
+ 1.426600000000e-05 8.704182428332e-01
+ 1.426700000000e-05 8.704792220484e-01
+ 1.426800000000e-05 8.705402012636e-01
+ 1.426900000000e-05 8.706011804788e-01
+ 1.427000000000e-05 8.706621596941e-01
+ 1.427100000000e-05 8.707231389093e-01
+ 1.427200000000e-05 8.707841181245e-01
+ 1.427300000000e-05 8.708450973397e-01
+ 1.427400000000e-05 8.709060765549e-01
+ 1.427500000000e-05 8.709670557701e-01
+ 1.427600000000e-05 8.710280349854e-01
+ 1.427700000000e-05 8.710890142006e-01
+ 1.427800000000e-05 8.711499934158e-01
+ 1.427900000000e-05 8.712109726310e-01
+ 1.428000000000e-05 8.712719518462e-01
+ 1.428100000000e-05 8.713329310614e-01
+ 1.428200000000e-05 8.713939102767e-01
+ 1.428300000000e-05 8.714548894919e-01
+ 1.428400000000e-05 8.715158687071e-01
+ 1.428500000000e-05 8.715768479223e-01
+ 1.428600000000e-05 8.716378271375e-01
+ 1.428700000000e-05 8.716988063527e-01
+ 1.428800000000e-05 8.717597855680e-01
+ 1.428900000000e-05 8.718207647832e-01
+ 1.429000000000e-05 8.718817439984e-01
+ 1.429100000000e-05 8.719427232136e-01
+ 1.429200000000e-05 8.720037024288e-01
+ 1.429300000000e-05 8.720646816440e-01
+ 1.429400000000e-05 8.721256608593e-01
+ 1.429500000000e-05 8.721866400745e-01
+ 1.429600000000e-05 8.722476192897e-01
+ 1.429700000000e-05 8.723085985049e-01
+ 1.429800000000e-05 8.723695777201e-01
+ 1.429900000000e-05 8.724305569353e-01
+ 1.430000000000e-05 8.724915361506e-01
+ 1.430100000000e-05 8.725525153658e-01
+ 1.430200000000e-05 8.726134945810e-01
+ 1.430300000000e-05 8.726744737962e-01
+ 1.430400000000e-05 8.727354530114e-01
+ 1.430500000000e-05 8.727964322266e-01
+ 1.430600000000e-05 8.728574114419e-01
+ 1.430700000000e-05 8.729183906571e-01
+ 1.430800000000e-05 8.729793698723e-01
+ 1.430900000000e-05 8.730403490875e-01
+ 1.431000000000e-05 8.731013283027e-01
+ 1.431100000000e-05 8.731623075179e-01
+ 1.431200000000e-05 8.732232867332e-01
+ 1.431300000000e-05 8.732842659484e-01
+ 1.431400000000e-05 8.733452451636e-01
+ 1.431500000000e-05 8.734062243788e-01
+ 1.431600000000e-05 8.734672035940e-01
+ 1.431700000000e-05 8.735281828092e-01
+ 1.431800000000e-05 8.735891620245e-01
+ 1.431900000000e-05 8.736501412397e-01
+ 1.432000000000e-05 8.737111204549e-01
+ 1.432100000000e-05 8.737720996701e-01
+ 1.432200000000e-05 8.738330788853e-01
+ 1.432300000000e-05 8.738940581005e-01
+ 1.432400000000e-05 8.739550373158e-01
+ 1.432500000000e-05 8.740160165310e-01
+ 1.432600000000e-05 8.740769957462e-01
+ 1.432700000000e-05 8.741379749614e-01
+ 1.432800000000e-05 8.741989541766e-01
+ 1.432900000000e-05 8.742599333918e-01
+ 1.433000000000e-05 8.743209126071e-01
+ 1.433100000000e-05 8.743818918223e-01
+ 1.433200000000e-05 8.744428710375e-01
+ 1.433300000000e-05 8.745038502527e-01
+ 1.433400000000e-05 8.745648294679e-01
+ 1.433500000000e-05 8.746258086831e-01
+ 1.433600000000e-05 8.746867878984e-01
+ 1.433700000000e-05 8.747477671136e-01
+ 1.433800000000e-05 8.748087463288e-01
+ 1.433900000000e-05 8.748697255440e-01
+ 1.434000000000e-05 8.749307047592e-01
+ 1.434100000000e-05 8.749916839744e-01
+ 1.434200000000e-05 8.750526631897e-01
+ 1.434300000000e-05 8.751136424049e-01
+ 1.434400000000e-05 8.751746216201e-01
+ 1.434500000000e-05 8.752356008353e-01
+ 1.434600000000e-05 8.752965800505e-01
+ 1.434700000000e-05 8.753575592657e-01
+ 1.434800000000e-05 8.754185384810e-01
+ 1.434900000000e-05 8.754795176962e-01
+ 1.435000000000e-05 8.755404969114e-01
+ 1.435100000000e-05 8.756014761266e-01
+ 1.435200000000e-05 8.756624553418e-01
+ 1.435300000000e-05 8.757234345570e-01
+ 1.435400000000e-05 8.757844137723e-01
+ 1.435500000000e-05 8.758453929875e-01
+ 1.435600000000e-05 8.759063722027e-01
+ 1.435700000000e-05 8.759673514179e-01
+ 1.435800000000e-05 8.760283306331e-01
+ 1.435900000000e-05 8.760893098483e-01
+ 1.436000000000e-05 8.761502890636e-01
+ 1.436100000000e-05 8.762112682788e-01
+ 1.436200000000e-05 8.762722474940e-01
+ 1.436300000000e-05 8.763332267092e-01
+ 1.436400000000e-05 8.763942059244e-01
+ 1.436500000000e-05 8.764551851396e-01
+ 1.436600000000e-05 8.765161643549e-01
+ 1.436700000000e-05 8.765771435701e-01
+ 1.436800000000e-05 8.766381227853e-01
+ 1.436900000000e-05 8.766991020005e-01
+ 1.437000000000e-05 8.767600812157e-01
+ 1.437100000000e-05 8.768210604309e-01
+ 1.437200000000e-05 8.768820396462e-01
+ 1.437300000000e-05 8.769430188614e-01
+ 1.437400000000e-05 8.770039980766e-01
+ 1.437500000000e-05 8.770649772918e-01
+ 1.437600000000e-05 8.771259565070e-01
+ 1.437700000000e-05 8.771869357222e-01
+ 1.437800000000e-05 8.772479149375e-01
+ 1.437900000000e-05 8.773088941527e-01
+ 1.438000000000e-05 8.773698733679e-01
+ 1.438100000000e-05 8.774308525831e-01
+ 1.438200000000e-05 8.774918317983e-01
+ 1.438300000000e-05 8.775528110135e-01
+ 1.438400000000e-05 8.776137902288e-01
+ 1.438500000000e-05 8.776747694440e-01
+ 1.438600000000e-05 8.777357486592e-01
+ 1.438700000000e-05 8.777967278744e-01
+ 1.438800000000e-05 8.778577070896e-01
+ 1.438900000000e-05 8.779186863048e-01
+ 1.439000000000e-05 8.779796655201e-01
+ 1.439100000000e-05 8.780406447353e-01
+ 1.439200000000e-05 8.781016239505e-01
+ 1.439300000000e-05 8.781626031657e-01
+ 1.439400000000e-05 8.782235823809e-01
+ 1.439500000000e-05 8.782845615961e-01
+ 1.439600000000e-05 8.783455408114e-01
+ 1.439700000000e-05 8.784065200266e-01
+ 1.439800000000e-05 8.784674992418e-01
+ 1.439900000000e-05 8.785284784570e-01
+ 1.440000000000e-05 8.785894576722e-01
+ 1.440100000000e-05 8.786504368874e-01
+ 1.440200000000e-05 8.787114161027e-01
+ 1.440300000000e-05 8.787723953179e-01
+ 1.440400000000e-05 8.788333745331e-01
+ 1.440500000000e-05 8.788943537483e-01
+ 1.440600000000e-05 8.789553329635e-01
+ 1.440700000000e-05 8.790163121787e-01
+ 1.440800000000e-05 8.790772913940e-01
+ 1.440900000000e-05 8.791382706092e-01
+ 1.441000000000e-05 8.791992498244e-01
+ 1.441100000000e-05 8.792602290396e-01
+ 1.441200000000e-05 8.793212082548e-01
+ 1.441300000000e-05 8.793821874700e-01
+ 1.441400000000e-05 8.794431666853e-01
+ 1.441500000000e-05 8.795041459005e-01
+ 1.441600000000e-05 8.795651251157e-01
+ 1.441700000000e-05 8.796261043309e-01
+ 1.441800000000e-05 8.796870835461e-01
+ 1.441900000000e-05 8.797480627613e-01
+ 1.442000000000e-05 8.798090419766e-01
+ 1.442100000000e-05 8.798700211918e-01
+ 1.442200000000e-05 8.799310004070e-01
+ 1.442300000000e-05 8.799919796222e-01
+ 1.442400000000e-05 8.800529588374e-01
+ 1.442500000000e-05 8.801139380526e-01
+ 1.442600000000e-05 8.801749172679e-01
+ 1.442700000000e-05 8.802358964831e-01
+ 1.442800000000e-05 8.802968756983e-01
+ 1.442900000000e-05 8.803578549135e-01
+ 1.443000000000e-05 8.804188341287e-01
+ 1.443100000000e-05 8.804798133439e-01
+ 1.443200000000e-05 8.805407925592e-01
+ 1.443300000000e-05 8.806017717744e-01
+ 1.443400000000e-05 8.806627509896e-01
+ 1.443500000000e-05 8.807237302048e-01
+ 1.443600000000e-05 8.807847094200e-01
+ 1.443700000000e-05 8.808456886352e-01
+ 1.443800000000e-05 8.809066678505e-01
+ 1.443900000000e-05 8.809676470657e-01
+ 1.444000000000e-05 8.810286262809e-01
+ 1.444100000000e-05 8.810896054961e-01
+ 1.444200000000e-05 8.811505847113e-01
+ 1.444300000000e-05 8.812115639265e-01
+ 1.444400000000e-05 8.812725431418e-01
+ 1.444500000000e-05 8.813335223570e-01
+ 1.444600000000e-05 8.813945015722e-01
+ 1.444700000000e-05 8.814554807874e-01
+ 1.444800000000e-05 8.815164600026e-01
+ 1.444900000000e-05 8.815774392178e-01
+ 1.445000000000e-05 8.816384184331e-01
+ 1.445100000000e-05 8.816993976483e-01
+ 1.445200000000e-05 8.817603768635e-01
+ 1.445300000000e-05 8.818213560787e-01
+ 1.445400000000e-05 8.818823352939e-01
+ 1.445500000000e-05 8.819433145091e-01
+ 1.445600000000e-05 8.820042937243e-01
+ 1.445700000000e-05 8.820652729396e-01
+ 1.445800000000e-05 8.821262521548e-01
+ 1.445900000000e-05 8.821872313700e-01
+ 1.446000000000e-05 8.822482105852e-01
+ 1.446100000000e-05 8.823091898004e-01
+ 1.446200000000e-05 8.823701690156e-01
+ 1.446300000000e-05 8.824311482309e-01
+ 1.446400000000e-05 8.824921274461e-01
+ 1.446500000000e-05 8.825531066613e-01
+ 1.446600000000e-05 8.826140858765e-01
+ 1.446700000000e-05 8.826750650917e-01
+ 1.446800000000e-05 8.827360443069e-01
+ 1.446900000000e-05 8.827970235222e-01
+ 1.447000000000e-05 8.828580027374e-01
+ 1.447100000000e-05 8.829189819526e-01
+ 1.447200000000e-05 8.829799611678e-01
+ 1.447300000000e-05 8.830409403830e-01
+ 1.447400000000e-05 8.831019195982e-01
+ 1.447500000000e-05 8.831628988135e-01
+ 1.447600000000e-05 8.832238780287e-01
+ 1.447700000000e-05 8.832848572439e-01
+ 1.447800000000e-05 8.833458364591e-01
+ 1.447900000000e-05 8.834068156743e-01
+ 1.448000000000e-05 8.834677948895e-01
+ 1.448100000000e-05 8.835287741048e-01
+ 1.448200000000e-05 8.835897533200e-01
+ 1.448300000000e-05 8.836507325352e-01
+ 1.448400000000e-05 8.837117117504e-01
+ 1.448500000000e-05 8.837726909656e-01
+ 1.448600000000e-05 8.838336701808e-01
+ 1.448700000000e-05 8.838946493961e-01
+ 1.448800000000e-05 8.839556286113e-01
+ 1.448900000000e-05 8.840166078265e-01
+ 1.449000000000e-05 8.840775870417e-01
+ 1.449100000000e-05 8.841385662569e-01
+ 1.449200000000e-05 8.841995454721e-01
+ 1.449300000000e-05 8.842605246874e-01
+ 1.449400000000e-05 8.843215039026e-01
+ 1.449500000000e-05 8.843824831178e-01
+ 1.449600000000e-05 8.844434623330e-01
+ 1.449700000000e-05 8.845044415482e-01
+ 1.449800000000e-05 8.845654207634e-01
+ 1.449900000000e-05 8.846263999787e-01
+ 1.450000000000e-05 8.846873791939e-01
+ 1.450100000000e-05 8.847483584091e-01
+ 1.450200000000e-05 8.848093376243e-01
+ 1.450300000000e-05 8.848703168395e-01
+ 1.450400000000e-05 8.849312960547e-01
+ 1.450500000000e-05 8.849922752700e-01
+ 1.450600000000e-05 8.850532544852e-01
+ 1.450700000000e-05 8.851142337004e-01
+ 1.450800000000e-05 8.851752129156e-01
+ 1.450900000000e-05 8.852361921308e-01
+ 1.451000000000e-05 8.852971713460e-01
+ 1.451100000000e-05 8.853581505613e-01
+ 1.451200000000e-05 8.854191297765e-01
+ 1.451300000000e-05 8.854801089917e-01
+ 1.451400000000e-05 8.855410882069e-01
+ 1.451500000000e-05 8.856020674221e-01
+ 1.451600000000e-05 8.856630466373e-01
+ 1.451700000000e-05 8.857240258526e-01
+ 1.451800000000e-05 8.857850050678e-01
+ 1.451900000000e-05 8.858459842830e-01
+ 1.452000000000e-05 8.859069634982e-01
+ 1.452100000000e-05 8.859679427134e-01
+ 1.452200000000e-05 8.860289219286e-01
+ 1.452300000000e-05 8.860899011439e-01
+ 1.452400000000e-05 8.861508803591e-01
+ 1.452500000000e-05 8.862118595743e-01
+ 1.452600000000e-05 8.862728387895e-01
+ 1.452700000000e-05 8.863338180047e-01
+ 1.452800000000e-05 8.863947972199e-01
+ 1.452900000000e-05 8.864557764352e-01
+ 1.453000000000e-05 8.865167556504e-01
+ 1.453100000000e-05 8.865777348656e-01
+ 1.453200000000e-05 8.866387140808e-01
+ 1.453300000000e-05 8.866996932960e-01
+ 1.453400000000e-05 8.867606725112e-01
+ 1.453500000000e-05 8.868216517265e-01
+ 1.453600000000e-05 8.868826309417e-01
+ 1.453700000000e-05 8.869436101569e-01
+ 1.453800000000e-05 8.870045893721e-01
+ 1.453900000000e-05 8.870655685873e-01
+ 1.454000000000e-05 8.871265478025e-01
+ 1.454100000000e-05 8.871875270178e-01
+ 1.454200000000e-05 8.872485062330e-01
+ 1.454300000000e-05 8.873094854482e-01
+ 1.454400000000e-05 8.873704646634e-01
+ 1.454500000000e-05 8.874314438786e-01
+ 1.454600000000e-05 8.874924230938e-01
+ 1.454700000000e-05 8.875534023091e-01
+ 1.454800000000e-05 8.876143815243e-01
+ 1.454900000000e-05 8.876753607395e-01
+ 1.455000000000e-05 8.877363399547e-01
+ 1.455100000000e-05 8.877973191699e-01
+ 1.455200000000e-05 8.878582983851e-01
+ 1.455300000000e-05 8.879192776004e-01
+ 1.455400000000e-05 8.879802568156e-01
+ 1.455500000000e-05 8.880412360308e-01
+ 1.455600000000e-05 8.881022152460e-01
+ 1.455700000000e-05 8.881631944612e-01
+ 1.455800000000e-05 8.882241736764e-01
+ 1.455900000000e-05 8.882851528917e-01
+ 1.456000000000e-05 8.883461321069e-01
+ 1.456100000000e-05 8.884071113221e-01
+ 1.456200000000e-05 8.884680905373e-01
+ 1.456300000000e-05 8.885290697525e-01
+ 1.456400000000e-05 8.885900489677e-01
+ 1.456500000000e-05 8.886510281830e-01
+ 1.456600000000e-05 8.887120073982e-01
+ 1.456700000000e-05 8.887729866134e-01
+ 1.456800000000e-05 8.888339658286e-01
+ 1.456900000000e-05 8.888949450438e-01
+ 1.457000000000e-05 8.889559242590e-01
+ 1.457100000000e-05 8.890169034743e-01
+ 1.457200000000e-05 8.890778826895e-01
+ 1.457300000000e-05 8.891388619047e-01
+ 1.457400000000e-05 8.891998411199e-01
+ 1.457500000000e-05 8.892608203351e-01
+ 1.457600000000e-05 8.893217995503e-01
+ 1.457700000000e-05 8.893827787656e-01
+ 1.457800000000e-05 8.894437579808e-01
+ 1.457900000000e-05 8.895047371960e-01
+ 1.458000000000e-05 8.895657164112e-01
+ 1.458100000000e-05 8.896266956264e-01
+ 1.458200000000e-05 8.896876748416e-01
+ 1.458300000000e-05 8.897486540569e-01
+ 1.458400000000e-05 8.898096332721e-01
+ 1.458500000000e-05 8.898706124873e-01
+ 1.458600000000e-05 8.899315917025e-01
+ 1.458700000000e-05 8.899925709177e-01
+ 1.458800000000e-05 8.900535501329e-01
+ 1.458900000000e-05 8.901145293482e-01
+ 1.459000000000e-05 8.901755085634e-01
+ 1.459100000000e-05 8.902364877786e-01
+ 1.459200000000e-05 8.902974669938e-01
+ 1.459300000000e-05 8.903584462090e-01
+ 1.459400000000e-05 8.904194254242e-01
+ 1.459500000000e-05 8.904804046395e-01
+ 1.459600000000e-05 8.905413838547e-01
+ 1.459700000000e-05 8.906023630699e-01
+ 1.459800000000e-05 8.906633422851e-01
+ 1.459900000000e-05 8.907243215003e-01
+ 1.460000000000e-05 8.907853007155e-01
+ 1.460100000000e-05 8.908462799308e-01
+ 1.460200000000e-05 8.909072591460e-01
+ 1.460300000000e-05 8.909682383612e-01
+ 1.460400000000e-05 8.910292175764e-01
+ 1.460500000000e-05 8.910901967916e-01
+ 1.460600000000e-05 8.911511760068e-01
+ 1.460700000000e-05 8.912121552221e-01
+ 1.460800000000e-05 8.912731344373e-01
+ 1.460900000000e-05 8.913341136525e-01
+ 1.461000000000e-05 8.913950928677e-01
+ 1.461100000000e-05 8.914560720829e-01
+ 1.461200000000e-05 8.915170512981e-01
+ 1.461300000000e-05 8.915780305134e-01
+ 1.461400000000e-05 8.916390097286e-01
+ 1.461500000000e-05 8.916999889438e-01
+ 1.461600000000e-05 8.917609681590e-01
+ 1.461700000000e-05 8.918219473742e-01
+ 1.461800000000e-05 8.918829265894e-01
+ 1.461900000000e-05 8.919439058047e-01
+ 1.462000000000e-05 8.920048850199e-01
+ 1.462100000000e-05 8.920658642351e-01
+ 1.462200000000e-05 8.921268434503e-01
+ 1.462300000000e-05 8.921878226655e-01
+ 1.462400000000e-05 8.922488018807e-01
+ 1.462500000000e-05 8.923097810960e-01
+ 1.462600000000e-05 8.923707603112e-01
+ 1.462700000000e-05 8.924317395264e-01
+ 1.462800000000e-05 8.924927187416e-01
+ 1.462900000000e-05 8.925536979568e-01
+ 1.463000000000e-05 8.926146771720e-01
+ 1.463100000000e-05 8.926756563873e-01
+ 1.463200000000e-05 8.927366356025e-01
+ 1.463300000000e-05 8.927976148177e-01
+ 1.463400000000e-05 8.928585940329e-01
+ 1.463500000000e-05 8.929195732481e-01
+ 1.463600000000e-05 8.929805524633e-01
+ 1.463700000000e-05 8.930415316786e-01
+ 1.463800000000e-05 8.931025108938e-01
+ 1.463900000000e-05 8.931634901090e-01
+ 1.464000000000e-05 8.932244693242e-01
+ 1.464100000000e-05 8.932854485394e-01
+ 1.464200000000e-05 8.933464277546e-01
+ 1.464300000000e-05 8.934074069699e-01
+ 1.464400000000e-05 8.934683861851e-01
+ 1.464500000000e-05 8.935293654003e-01
+ 1.464600000000e-05 8.935903446155e-01
+ 1.464700000000e-05 8.936513238307e-01
+ 1.464800000000e-05 8.937123030459e-01
+ 1.464900000000e-05 8.937732822612e-01
+ 1.465000000000e-05 8.938342614764e-01
+ 1.465100000000e-05 8.938952406916e-01
+ 1.465200000000e-05 8.939562199068e-01
+ 1.465300000000e-05 8.940171991220e-01
+ 1.465400000000e-05 8.940781783372e-01
+ 1.465500000000e-05 8.941391575525e-01
+ 1.465600000000e-05 8.942001367677e-01
+ 1.465700000000e-05 8.942611159829e-01
+ 1.465800000000e-05 8.943220951981e-01
+ 1.465900000000e-05 8.943830744133e-01
+ 1.466000000000e-05 8.944440536285e-01
+ 1.466100000000e-05 8.945050328438e-01
+ 1.466200000000e-05 8.945660120590e-01
+ 1.466300000000e-05 8.946269912742e-01
+ 1.466400000000e-05 8.946879704894e-01
+ 1.466500000000e-05 8.947489497046e-01
+ 1.466600000000e-05 8.948099289198e-01
+ 1.466700000000e-05 8.948709081351e-01
+ 1.466800000000e-05 8.949318873503e-01
+ 1.466900000000e-05 8.949928665655e-01
+ 1.467000000000e-05 8.950538457807e-01
+ 1.467100000000e-05 8.951148249959e-01
+ 1.467200000000e-05 8.951758042111e-01
+ 1.467300000000e-05 8.952367834264e-01
+ 1.467400000000e-05 8.952977626416e-01
+ 1.467500000000e-05 8.953587418568e-01
+ 1.467600000000e-05 8.954197210720e-01
+ 1.467700000000e-05 8.954807002872e-01
+ 1.467800000000e-05 8.955416795024e-01
+ 1.467900000000e-05 8.956026587177e-01
+ 1.468000000000e-05 8.956636379329e-01
+ 1.468100000000e-05 8.957246171481e-01
+ 1.468200000000e-05 8.957855963633e-01
+ 1.468300000000e-05 8.958465755785e-01
+ 1.468400000000e-05 8.959075547937e-01
+ 1.468500000000e-05 8.959685340089e-01
+ 1.468600000000e-05 8.960295132242e-01
+ 1.468700000000e-05 8.960904924394e-01
+ 1.468800000000e-05 8.961514716546e-01
+ 1.468900000000e-05 8.962124508698e-01
+ 1.469000000000e-05 8.962734300850e-01
+ 1.469100000000e-05 8.963344093002e-01
+ 1.469200000000e-05 8.963953885155e-01
+ 1.469300000000e-05 8.964563677307e-01
+ 1.469400000000e-05 8.965173469459e-01
+ 1.469500000000e-05 8.965783261611e-01
+ 1.469600000000e-05 8.966393053763e-01
+ 1.469700000000e-05 8.967002845915e-01
+ 1.469800000000e-05 8.967612638068e-01
+ 1.469900000000e-05 8.968222430220e-01
+ 1.470000000000e-05 8.968832222372e-01
+ 1.470100000000e-05 8.969442014524e-01
+ 1.470200000000e-05 8.970051806676e-01
+ 1.470300000000e-05 8.970661598828e-01
+ 1.470400000000e-05 8.971271390981e-01
+ 1.470500000000e-05 8.971881183133e-01
+ 1.470600000000e-05 8.972490975285e-01
+ 1.470700000000e-05 8.973100767437e-01
+ 1.470800000000e-05 8.973710559589e-01
+ 1.470900000000e-05 8.974320351741e-01
+ 1.471000000000e-05 8.974930143894e-01
+ 1.471100000000e-05 8.975539936046e-01
+ 1.471200000000e-05 8.976149728198e-01
+ 1.471300000000e-05 8.976759520350e-01
+ 1.471400000000e-05 8.977369312502e-01
+ 1.471500000000e-05 8.977979104654e-01
+ 1.471600000000e-05 8.978588896807e-01
+ 1.471700000000e-05 8.979198688959e-01
+ 1.471800000000e-05 8.979808481111e-01
+ 1.471900000000e-05 8.980418273263e-01
+ 1.472000000000e-05 8.981028065415e-01
+ 1.472100000000e-05 8.981637857567e-01
+ 1.472200000000e-05 8.982247649720e-01
+ 1.472300000000e-05 8.982857441872e-01
+ 1.472400000000e-05 8.983467234024e-01
+ 1.472500000000e-05 8.984077026176e-01
+ 1.472600000000e-05 8.984686818328e-01
+ 1.472700000000e-05 8.985296610480e-01
+ 1.472800000000e-05 8.985906402633e-01
+ 1.472900000000e-05 8.986516194785e-01
+ 1.473000000000e-05 8.987125986937e-01
+ 1.473100000000e-05 8.987735779089e-01
+ 1.473200000000e-05 8.988345571241e-01
+ 1.473300000000e-05 8.988955363393e-01
+ 1.473400000000e-05 8.989565155546e-01
+ 1.473500000000e-05 8.990174947698e-01
+ 1.473600000000e-05 8.990784739850e-01
+ 1.473700000000e-05 8.991394532002e-01
+ 1.473800000000e-05 8.992004324154e-01
+ 1.473900000000e-05 8.992614116306e-01
+ 1.474000000000e-05 8.993223908459e-01
+ 1.474100000000e-05 8.993833700611e-01
+ 1.474200000000e-05 8.994443492763e-01
+ 1.474300000000e-05 8.995053284915e-01
+ 1.474400000000e-05 8.995663077067e-01
+ 1.474500000000e-05 8.996272869219e-01
+ 1.474600000000e-05 8.996882661372e-01
+ 1.474700000000e-05 8.997492453524e-01
+ 1.474800000000e-05 8.998102245676e-01
+ 1.474900000000e-05 8.998712037828e-01
+ 1.475000000000e-05 8.999321829980e-01
+ 1.475100000000e-05 8.999931622132e-01
+ 1.475200000000e-05 9.000541414285e-01
+ 1.475300000000e-05 9.001151206437e-01
+ 1.475400000000e-05 9.001760998589e-01
+ 1.475500000000e-05 9.002370790741e-01
+ 1.475600000000e-05 9.002980582893e-01
+ 1.475700000000e-05 9.003590375045e-01
+ 1.475800000000e-05 9.004200167198e-01
+ 1.475900000000e-05 9.004809959350e-01
+ 1.476000000000e-05 9.005419751502e-01
+ 1.476100000000e-05 9.006029543654e-01
+ 1.476200000000e-05 9.006639335806e-01
+ 1.476300000000e-05 9.007249127958e-01
+ 1.476400000000e-05 9.007858920111e-01
+ 1.476500000000e-05 9.008468712263e-01
+ 1.476600000000e-05 9.009078504415e-01
+ 1.476700000000e-05 9.009688296567e-01
+ 1.476800000000e-05 9.010298088719e-01
+ 1.476900000000e-05 9.010907880871e-01
+ 1.477000000000e-05 9.011517673024e-01
+ 1.477100000000e-05 9.012127465176e-01
+ 1.477200000000e-05 9.012737257328e-01
+ 1.477300000000e-05 9.013347049480e-01
+ 1.477400000000e-05 9.013956841632e-01
+ 1.477500000000e-05 9.014566633784e-01
+ 1.477600000000e-05 9.015176425937e-01
+ 1.477700000000e-05 9.015786218089e-01
+ 1.477800000000e-05 9.016396010241e-01
+ 1.477900000000e-05 9.017005802393e-01
+ 1.478000000000e-05 9.017615594545e-01
+ 1.478100000000e-05 9.018225386697e-01
+ 1.478200000000e-05 9.018835178850e-01
+ 1.478300000000e-05 9.019444971002e-01
+ 1.478400000000e-05 9.020054763154e-01
+ 1.478500000000e-05 9.020664555306e-01
+ 1.478600000000e-05 9.021274347458e-01
+ 1.478700000000e-05 9.021884139610e-01
+ 1.478800000000e-05 9.022493931763e-01
+ 1.478900000000e-05 9.023103723915e-01
+ 1.479000000000e-05 9.023713516067e-01
+ 1.479100000000e-05 9.024323308219e-01
+ 1.479200000000e-05 9.024933100371e-01
+ 1.479300000000e-05 9.025542892523e-01
+ 1.479400000000e-05 9.026152684676e-01
+ 1.479500000000e-05 9.026762476828e-01
+ 1.479600000000e-05 9.027372268980e-01
+ 1.479700000000e-05 9.027982061132e-01
+ 1.479800000000e-05 9.028591853284e-01
+ 1.479900000000e-05 9.029201645436e-01
+ 1.480000000000e-05 9.029811437589e-01
+ 1.480100000000e-05 9.030421229741e-01
+ 1.480200000000e-05 9.031031021893e-01
+ 1.480300000000e-05 9.031640814045e-01
+ 1.480400000000e-05 9.032250606197e-01
+ 1.480500000000e-05 9.032860398349e-01
+ 1.480600000000e-05 9.033470190502e-01
+ 1.480700000000e-05 9.034079982654e-01
+ 1.480800000000e-05 9.034689774806e-01
+ 1.480900000000e-05 9.035299566958e-01
+ 1.481000000000e-05 9.035909359110e-01
+ 1.481100000000e-05 9.036519151262e-01
+ 1.481200000000e-05 9.037128943415e-01
+ 1.481300000000e-05 9.037738735567e-01
+ 1.481400000000e-05 9.038348527719e-01
+ 1.481500000000e-05 9.038958319871e-01
+ 1.481600000000e-05 9.039568112023e-01
+ 1.481700000000e-05 9.040177904175e-01
+ 1.481800000000e-05 9.040787696328e-01
+ 1.481900000000e-05 9.041397488480e-01
+ 1.482000000000e-05 9.042007280632e-01
+ 1.482100000000e-05 9.042617072784e-01
+ 1.482200000000e-05 9.043226864936e-01
+ 1.482300000000e-05 9.043836657088e-01
+ 1.482400000000e-05 9.044446449241e-01
+ 1.482500000000e-05 9.045056241393e-01
+ 1.482600000000e-05 9.045666033545e-01
+ 1.482700000000e-05 9.046275825697e-01
+ 1.482800000000e-05 9.046885617849e-01
+ 1.482900000000e-05 9.047495410001e-01
+ 1.483000000000e-05 9.048105202154e-01
+ 1.483100000000e-05 9.048714994306e-01
+ 1.483200000000e-05 9.049324786458e-01
+ 1.483300000000e-05 9.049934578610e-01
+ 1.483400000000e-05 9.050544370762e-01
+ 1.483500000000e-05 9.051154162914e-01
+ 1.483600000000e-05 9.051763955067e-01
+ 1.483700000000e-05 9.052373747219e-01
+ 1.483800000000e-05 9.052983539371e-01
+ 1.483900000000e-05 9.053593331523e-01
+ 1.484000000000e-05 9.054203123675e-01
+ 1.484100000000e-05 9.054812915827e-01
+ 1.484200000000e-05 9.055422707980e-01
+ 1.484300000000e-05 9.056032500132e-01
+ 1.484400000000e-05 9.056642292284e-01
+ 1.484500000000e-05 9.057252084436e-01
+ 1.484600000000e-05 9.057861876588e-01
+ 1.484700000000e-05 9.058471668740e-01
+ 1.484800000000e-05 9.059081460893e-01
+ 1.484900000000e-05 9.059691253045e-01
+ 1.485000000000e-05 9.060301045197e-01
+ 1.485100000000e-05 9.060910837349e-01
+ 1.485200000000e-05 9.061520629501e-01
+ 1.485300000000e-05 9.062130421653e-01
+ 1.485400000000e-05 9.062740213806e-01
+ 1.485500000000e-05 9.063350005958e-01
+ 1.485600000000e-05 9.063959798110e-01
+ 1.485700000000e-05 9.064569590262e-01
+ 1.485800000000e-05 9.065179382414e-01
+ 1.485900000000e-05 9.065789174566e-01
+ 1.486000000000e-05 9.066398966719e-01
+ 1.486100000000e-05 9.067008758871e-01
+ 1.486200000000e-05 9.067618551023e-01
+ 1.486300000000e-05 9.068228343175e-01
+ 1.486400000000e-05 9.068838135327e-01
+ 1.486500000000e-05 9.069447927479e-01
+ 1.486600000000e-05 9.070057719632e-01
+ 1.486700000000e-05 9.070667511784e-01
+ 1.486800000000e-05 9.071277303936e-01
+ 1.486900000000e-05 9.071887096088e-01
+ 1.487000000000e-05 9.072496888240e-01
+ 1.487100000000e-05 9.073106680392e-01
+ 1.487200000000e-05 9.073716472545e-01
+ 1.487300000000e-05 9.074326264697e-01
+ 1.487400000000e-05 9.074936056849e-01
+ 1.487500000000e-05 9.075545849001e-01
+ 1.487600000000e-05 9.076155641153e-01
+ 1.487700000000e-05 9.076765433305e-01
+ 1.487800000000e-05 9.077375225458e-01
+ 1.487900000000e-05 9.077985017610e-01
+ 1.488000000000e-05 9.078594809762e-01
+ 1.488100000000e-05 9.079204601914e-01
+ 1.488200000000e-05 9.079814394066e-01
+ 1.488300000000e-05 9.080424186218e-01
+ 1.488400000000e-05 9.081033978371e-01
+ 1.488500000000e-05 9.081643770523e-01
+ 1.488600000000e-05 9.082253562675e-01
+ 1.488700000000e-05 9.082863354827e-01
+ 1.488800000000e-05 9.083473146979e-01
+ 1.488900000000e-05 9.084082939131e-01
+ 1.489000000000e-05 9.084692731284e-01
+ 1.489100000000e-05 9.085302523436e-01
+ 1.489200000000e-05 9.085912315588e-01
+ 1.489300000000e-05 9.086522107740e-01
+ 1.489400000000e-05 9.087131899892e-01
+ 1.489500000000e-05 9.087741692044e-01
+ 1.489600000000e-05 9.088351484197e-01
+ 1.489700000000e-05 9.088961276349e-01
+ 1.489800000000e-05 9.089571068501e-01
+ 1.489900000000e-05 9.090180860653e-01
+ 1.490000000000e-05 9.090790652805e-01
+ 1.490100000000e-05 9.091400444957e-01
+ 1.490200000000e-05 9.092010237110e-01
+ 1.490300000000e-05 9.092620029262e-01
+ 1.490400000000e-05 9.093229821414e-01
+ 1.490500000000e-05 9.093839613566e-01
+ 1.490600000000e-05 9.094449405718e-01
+ 1.490700000000e-05 9.095059197870e-01
+ 1.490800000000e-05 9.095668990022e-01
+ 1.490900000000e-05 9.096278782175e-01
+ 1.491000000000e-05 9.096888574327e-01
+ 1.491100000000e-05 9.097498366479e-01
+ 1.491200000000e-05 9.098108158631e-01
+ 1.491300000000e-05 9.098717950783e-01
+ 1.491400000000e-05 9.099327742935e-01
+ 1.491500000000e-05 9.099937535088e-01
+ 1.491600000000e-05 9.100547327240e-01
+ 1.491700000000e-05 9.101157119392e-01
+ 1.491800000000e-05 9.101766911544e-01
+ 1.491900000000e-05 9.102376703696e-01
+ 1.492000000000e-05 9.102986495848e-01
+ 1.492100000000e-05 9.103596288001e-01
+ 1.492200000000e-05 9.104206080153e-01
+ 1.492300000000e-05 9.104815872305e-01
+ 1.492400000000e-05 9.105425664457e-01
+ 1.492500000000e-05 9.106035456609e-01
+ 1.492600000000e-05 9.106645248761e-01
+ 1.492700000000e-05 9.107255040914e-01
+ 1.492800000000e-05 9.107864833066e-01
+ 1.492900000000e-05 9.108474625218e-01
+ 1.493000000000e-05 9.109084417370e-01
+ 1.493100000000e-05 9.109694209522e-01
+ 1.493200000000e-05 9.110304001674e-01
+ 1.493300000000e-05 9.110913793827e-01
+ 1.493400000000e-05 9.111523585979e-01
+ 1.493500000000e-05 9.112133378131e-01
+ 1.493600000000e-05 9.112743170283e-01
+ 1.493700000000e-05 9.113352962435e-01
+ 1.493800000000e-05 9.113962754587e-01
+ 1.493900000000e-05 9.114572546740e-01
+ 1.494000000000e-05 9.115182338892e-01
+ 1.494100000000e-05 9.115792131044e-01
+ 1.494200000000e-05 9.116401923196e-01
+ 1.494300000000e-05 9.117011715348e-01
+ 1.494400000000e-05 9.117621507500e-01
+ 1.494500000000e-05 9.118231299653e-01
+ 1.494600000000e-05 9.118841091805e-01
+ 1.494700000000e-05 9.119450883957e-01
+ 1.494800000000e-05 9.120060676109e-01
+ 1.494900000000e-05 9.120670468261e-01
+ 1.495000000000e-05 9.121280260413e-01
+ 1.495100000000e-05 9.121890052566e-01
+ 1.495200000000e-05 9.122499844718e-01
+ 1.495300000000e-05 9.123109636870e-01
+ 1.495400000000e-05 9.123719429022e-01
+ 1.495500000000e-05 9.124329221174e-01
+ 1.495600000000e-05 9.124939013326e-01
+ 1.495700000000e-05 9.125548805479e-01
+ 1.495800000000e-05 9.126158597631e-01
+ 1.495900000000e-05 9.126768389783e-01
+ 1.496000000000e-05 9.127378181935e-01
+ 1.496100000000e-05 9.127987974087e-01
+ 1.496200000000e-05 9.128597766239e-01
+ 1.496300000000e-05 9.129207558392e-01
+ 1.496400000000e-05 9.129817350544e-01
+ 1.496500000000e-05 9.130427142696e-01
+ 1.496600000000e-05 9.131036934848e-01
+ 1.496700000000e-05 9.131646727000e-01
+ 1.496800000000e-05 9.132256519152e-01
+ 1.496900000000e-05 9.132866311305e-01
+ 1.497000000000e-05 9.133476103457e-01
+ 1.497100000000e-05 9.134085895609e-01
+ 1.497200000000e-05 9.134695687761e-01
+ 1.497300000000e-05 9.135305479913e-01
+ 1.497400000000e-05 9.135915272065e-01
+ 1.497500000000e-05 9.136525064218e-01
+ 1.497600000000e-05 9.137134856370e-01
+ 1.497700000000e-05 9.137744648522e-01
+ 1.497800000000e-05 9.138354440674e-01
+ 1.497900000000e-05 9.138964232826e-01
+ 1.498000000000e-05 9.139574024978e-01
+ 1.498100000000e-05 9.140183817131e-01
+ 1.498200000000e-05 9.140793609283e-01
+ 1.498300000000e-05 9.141403401435e-01
+ 1.498400000000e-05 9.142013193587e-01
+ 1.498500000000e-05 9.142622985739e-01
+ 1.498600000000e-05 9.143232777891e-01
+ 1.498700000000e-05 9.143842570044e-01
+ 1.498800000000e-05 9.144452362196e-01
+ 1.498900000000e-05 9.145062154348e-01
+ 1.499000000000e-05 9.145671946500e-01
+ 1.499100000000e-05 9.146281738652e-01
+ 1.499200000000e-05 9.146891530804e-01
+ 1.499300000000e-05 9.147501322957e-01
+ 1.499400000000e-05 9.148111115109e-01
+ 1.499500000000e-05 9.148720907261e-01
+ 1.499600000000e-05 9.149330699413e-01
+ 1.499700000000e-05 9.149940491565e-01
+ 1.499800000000e-05 9.150550283717e-01
+ 1.499900000000e-05 9.151160075870e-01
+ 1.500000000000e-05 9.151769868022e-01
+ 1.500100000000e-05 9.152379660174e-01
+ 1.500200000000e-05 9.152989452326e-01
+ 1.500300000000e-05 9.153599244478e-01
+ 1.500400000000e-05 9.154209036630e-01
+ 1.500500000000e-05 9.154818828783e-01
+ 1.500600000000e-05 9.155428620935e-01
+ 1.500700000000e-05 9.156038413087e-01
+ 1.500800000000e-05 9.156648205239e-01
+ 1.500900000000e-05 9.157257997391e-01
+ 1.501000000000e-05 9.157867789543e-01
+ 1.501100000000e-05 9.158477581696e-01
+ 1.501200000000e-05 9.159087373848e-01
+ 1.501300000000e-05 9.159697166000e-01
+ 1.501400000000e-05 9.160306958152e-01
+ 1.501500000000e-05 9.160916750304e-01
+ 1.501600000000e-05 9.161526542456e-01
+ 1.501700000000e-05 9.162136334609e-01
+ 1.501800000000e-05 9.162746126761e-01
+ 1.501900000000e-05 9.163355918913e-01
+ 1.502000000000e-05 9.163965711065e-01
+ 1.502100000000e-05 9.164575503217e-01
+ 1.502200000000e-05 9.165185295369e-01
+ 1.502300000000e-05 9.165795087522e-01
+ 1.502400000000e-05 9.166404879674e-01
+ 1.502500000000e-05 9.167014671826e-01
+ 1.502600000000e-05 9.167624463978e-01
+ 1.502700000000e-05 9.168234256130e-01
+ 1.502800000000e-05 9.168844048282e-01
+ 1.502900000000e-05 9.169453840435e-01
+ 1.503000000000e-05 9.170063632587e-01
+ 1.503100000000e-05 9.170673424739e-01
+ 1.503200000000e-05 9.171283216891e-01
+ 1.503300000000e-05 9.171893009043e-01
+ 1.503400000000e-05 9.172502801195e-01
+ 1.503500000000e-05 9.173112593348e-01
+ 1.503600000000e-05 9.173722385500e-01
+ 1.503700000000e-05 9.174332177652e-01
+ 1.503800000000e-05 9.174941969804e-01
+ 1.503900000000e-05 9.175551761956e-01
+ 1.504000000000e-05 9.176161554108e-01
+ 1.504100000000e-05 9.176771346261e-01
+ 1.504200000000e-05 9.177381138413e-01
+ 1.504300000000e-05 9.177990930565e-01
+ 1.504400000000e-05 9.178600722717e-01
+ 1.504500000000e-05 9.179210514869e-01
+ 1.504600000000e-05 9.179820307021e-01
+ 1.504700000000e-05 9.180430099174e-01
+ 1.504800000000e-05 9.181039891326e-01
+ 1.504900000000e-05 9.181649683478e-01
+ 1.505000000000e-05 9.182259475630e-01
+ 1.505100000000e-05 9.182869267782e-01
+ 1.505200000000e-05 9.183479059934e-01
+ 1.505300000000e-05 9.184088852087e-01
+ 1.505400000000e-05 9.184698644239e-01
+ 1.505500000000e-05 9.185308436391e-01
+ 1.505600000000e-05 9.185918228543e-01
+ 1.505700000000e-05 9.186528020695e-01
+ 1.505800000000e-05 9.187137812847e-01
+ 1.505900000000e-05 9.187747605000e-01
+ 1.506000000000e-05 9.188357397152e-01
+ 1.506100000000e-05 9.188967189304e-01
+ 1.506200000000e-05 9.189576981456e-01
+ 1.506300000000e-05 9.190186773608e-01
+ 1.506400000000e-05 9.190796565760e-01
+ 1.506500000000e-05 9.191406357913e-01
+ 1.506600000000e-05 9.192016150065e-01
+ 1.506700000000e-05 9.192625942217e-01
+ 1.506800000000e-05 9.193235734369e-01
+ 1.506900000000e-05 9.193845526521e-01
+ 1.507000000000e-05 9.194455318673e-01
+ 1.507100000000e-05 9.195065110826e-01
+ 1.507200000000e-05 9.195674902978e-01
+ 1.507300000000e-05 9.196284695130e-01
+ 1.507400000000e-05 9.196894487282e-01
+ 1.507500000000e-05 9.197504279434e-01
+ 1.507600000000e-05 9.198114071586e-01
+ 1.507700000000e-05 9.198723863739e-01
+ 1.507800000000e-05 9.199333655891e-01
+ 1.507900000000e-05 9.199943448043e-01
+ 1.508000000000e-05 9.200553240195e-01
+ 1.508100000000e-05 9.201163032347e-01
+ 1.508200000000e-05 9.201772824499e-01
+ 1.508300000000e-05 9.202382616652e-01
+ 1.508400000000e-05 9.202992408804e-01
+ 1.508500000000e-05 9.203602200956e-01
+ 1.508600000000e-05 9.204211993108e-01
+ 1.508700000000e-05 9.204821785260e-01
+ 1.508800000000e-05 9.205431577412e-01
+ 1.508900000000e-05 9.206041369565e-01
+ 1.509000000000e-05 9.206651161717e-01
+ 1.509100000000e-05 9.207260953869e-01
+ 1.509200000000e-05 9.207870746021e-01
+ 1.509300000000e-05 9.208480538173e-01
+ 1.509400000000e-05 9.209090330325e-01
+ 1.509500000000e-05 9.209700122478e-01
+ 1.509600000000e-05 9.210309914630e-01
+ 1.509700000000e-05 9.210919706782e-01
+ 1.509800000000e-05 9.211529498934e-01
+ 1.509900000000e-05 9.212139291086e-01
+ 1.510000000000e-05 9.212749083238e-01
+ 1.510100000000e-05 9.213358875391e-01
+ 1.510200000000e-05 9.213968667543e-01
+ 1.510300000000e-05 9.214578459695e-01
+ 1.510400000000e-05 9.215188251847e-01
+ 1.510500000000e-05 9.215798043999e-01
+ 1.510600000000e-05 9.216407836151e-01
+ 1.510700000000e-05 9.217017628304e-01
+ 1.510800000000e-05 9.217627420456e-01
+ 1.510900000000e-05 9.218237212608e-01
+ 1.511000000000e-05 9.218847004760e-01
+ 1.511100000000e-05 9.219456796912e-01
+ 1.511200000000e-05 9.220066589064e-01
+ 1.511300000000e-05 9.220676381217e-01
+ 1.511400000000e-05 9.221286173369e-01
+ 1.511500000000e-05 9.221895965521e-01
+ 1.511600000000e-05 9.222505757673e-01
+ 1.511700000000e-05 9.223115549825e-01
+ 1.511800000000e-05 9.223725341977e-01
+ 1.511900000000e-05 9.224335134130e-01
+ 1.512000000000e-05 9.224944926282e-01
+ 1.512100000000e-05 9.225554718434e-01
+ 1.512200000000e-05 9.226164510586e-01
+ 1.512300000000e-05 9.226774302738e-01
+ 1.512400000000e-05 9.227384094890e-01
+ 1.512500000000e-05 9.227993887043e-01
+ 1.512600000000e-05 9.228603679195e-01
+ 1.512700000000e-05 9.229213471347e-01
+ 1.512800000000e-05 9.229823263499e-01
+ 1.512900000000e-05 9.230433055651e-01
+ 1.513000000000e-05 9.231042847803e-01
+ 1.513100000000e-05 9.231652639956e-01
+ 1.513200000000e-05 9.232262432108e-01
+ 1.513300000000e-05 9.232872224260e-01
+ 1.513400000000e-05 9.233482016412e-01
+ 1.513500000000e-05 9.234091808564e-01
+ 1.513600000000e-05 9.234701600716e-01
+ 1.513700000000e-05 9.235311392868e-01
+ 1.513800000000e-05 9.235921185021e-01
+ 1.513900000000e-05 9.236530977173e-01
+ 1.514000000000e-05 9.237140769325e-01
+ 1.514100000000e-05 9.237750561477e-01
+ 1.514200000000e-05 9.238360353629e-01
+ 1.514300000000e-05 9.238970145781e-01
+ 1.514400000000e-05 9.239579937934e-01
+ 1.514500000000e-05 9.240189730086e-01
+ 1.514600000000e-05 9.240799522238e-01
+ 1.514700000000e-05 9.241409314390e-01
+ 1.514800000000e-05 9.242019106542e-01
+ 1.514900000000e-05 9.242628898694e-01
+ 1.515000000000e-05 9.243238690847e-01
+ 1.515100000000e-05 9.243848482999e-01
+ 1.515200000000e-05 9.244458275151e-01
+ 1.515300000000e-05 9.245068067303e-01
+ 1.515400000000e-05 9.245677859455e-01
+ 1.515500000000e-05 9.246287651607e-01
+ 1.515600000000e-05 9.246897443760e-01
+ 1.515700000000e-05 9.247507235912e-01
+ 1.515800000000e-05 9.248117028064e-01
+ 1.515900000000e-05 9.248726820216e-01
+ 1.516000000000e-05 9.249336612368e-01
+ 1.516100000000e-05 9.249946404520e-01
+ 1.516200000000e-05 9.250556196673e-01
+ 1.516300000000e-05 9.251165988825e-01
+ 1.516400000000e-05 9.251775780977e-01
+ 1.516500000000e-05 9.252385573129e-01
+ 1.516600000000e-05 9.252995365281e-01
+ 1.516700000000e-05 9.253605157433e-01
+ 1.516800000000e-05 9.254214949586e-01
+ 1.516900000000e-05 9.254824741738e-01
+ 1.517000000000e-05 9.255434533890e-01
+ 1.517100000000e-05 9.256044326042e-01
+ 1.517200000000e-05 9.256654118194e-01
+ 1.517300000000e-05 9.257263910346e-01
+ 1.517400000000e-05 9.257873702499e-01
+ 1.517500000000e-05 9.258483494651e-01
+ 1.517600000000e-05 9.259093286803e-01
+ 1.517700000000e-05 9.259703078955e-01
+ 1.517800000000e-05 9.260312871107e-01
+ 1.517900000000e-05 9.260922663259e-01
+ 1.518000000000e-05 9.261532455412e-01
+ 1.518100000000e-05 9.262142247564e-01
+ 1.518200000000e-05 9.262752039716e-01
+ 1.518300000000e-05 9.263361831868e-01
+ 1.518400000000e-05 9.263971624020e-01
+ 1.518500000000e-05 9.264581416172e-01
+ 1.518600000000e-05 9.265191208325e-01
+ 1.518700000000e-05 9.265801000477e-01
+ 1.518800000000e-05 9.266410792629e-01
+ 1.518900000000e-05 9.267020584781e-01
+ 1.519000000000e-05 9.267630376933e-01
+ 1.519100000000e-05 9.268240169085e-01
+ 1.519200000000e-05 9.268849961238e-01
+ 1.519300000000e-05 9.269459753390e-01
+ 1.519400000000e-05 9.270069545542e-01
+ 1.519500000000e-05 9.270679337694e-01
+ 1.519600000000e-05 9.271289129846e-01
+ 1.519700000000e-05 9.271898921998e-01
+ 1.519800000000e-05 9.272508714151e-01
+ 1.519900000000e-05 9.273118506303e-01
+ 1.520000000000e-05 9.273728298455e-01
+ 1.520100000000e-05 9.274338090607e-01
+ 1.520200000000e-05 9.274947882759e-01
+ 1.520300000000e-05 9.275557674911e-01
+ 1.520400000000e-05 9.276167467064e-01
+ 1.520500000000e-05 9.276777259216e-01
+ 1.520600000000e-05 9.277387051368e-01
+ 1.520700000000e-05 9.277996843520e-01
+ 1.520800000000e-05 9.278606635672e-01
+ 1.520900000000e-05 9.279216427824e-01
+ 1.521000000000e-05 9.279826219977e-01
+ 1.521100000000e-05 9.280436012129e-01
+ 1.521200000000e-05 9.281045804281e-01
+ 1.521300000000e-05 9.281655596433e-01
+ 1.521400000000e-05 9.282265388585e-01
+ 1.521500000000e-05 9.282875180737e-01
+ 1.521600000000e-05 9.283484972890e-01
+ 1.521700000000e-05 9.284094765042e-01
+ 1.521800000000e-05 9.284704557194e-01
+ 1.521900000000e-05 9.285314349346e-01
+ 1.522000000000e-05 9.285924141498e-01
+ 1.522100000000e-05 9.286533933650e-01
+ 1.522200000000e-05 9.287143725803e-01
+ 1.522300000000e-05 9.287753517955e-01
+ 1.522400000000e-05 9.288363310107e-01
+ 1.522500000000e-05 9.288973102259e-01
+ 1.522600000000e-05 9.289582894411e-01
+ 1.522700000000e-05 9.290192686563e-01
+ 1.522800000000e-05 9.290802478716e-01
+ 1.522900000000e-05 9.291412270868e-01
+ 1.523000000000e-05 9.292022063020e-01
+ 1.523100000000e-05 9.292631855172e-01
+ 1.523200000000e-05 9.293241647324e-01
+ 1.523300000000e-05 9.293851439476e-01
+ 1.523400000000e-05 9.294461231629e-01
+ 1.523500000000e-05 9.295071023781e-01
+ 1.523600000000e-05 9.295680815933e-01
+ 1.523700000000e-05 9.296290608085e-01
+ 1.523800000000e-05 9.296900400237e-01
+ 1.523900000000e-05 9.297510192389e-01
+ 1.524000000000e-05 9.298119984542e-01
+ 1.524100000000e-05 9.298729776694e-01
+ 1.524200000000e-05 9.299339568846e-01
+ 1.524300000000e-05 9.299949360998e-01
+ 1.524400000000e-05 9.300559153150e-01
+ 1.524500000000e-05 9.301168945302e-01
+ 1.524600000000e-05 9.301778737455e-01
+ 1.524700000000e-05 9.302388529607e-01
+ 1.524800000000e-05 9.302998321759e-01
+ 1.524900000000e-05 9.303608113911e-01
+ 1.525000000000e-05 9.304217906063e-01
+ 1.525100000000e-05 9.304827698215e-01
+ 1.525200000000e-05 9.305437490368e-01
+ 1.525300000000e-05 9.306047282520e-01
+ 1.525400000000e-05 9.306657074672e-01
+ 1.525500000000e-05 9.307266866824e-01
+ 1.525600000000e-05 9.307876658976e-01
+ 1.525700000000e-05 9.308486451128e-01
+ 1.525800000000e-05 9.309096243281e-01
+ 1.525900000000e-05 9.309706035433e-01
+ 1.526000000000e-05 9.310315827585e-01
+ 1.526100000000e-05 9.310925619737e-01
+ 1.526200000000e-05 9.311535411889e-01
+ 1.526300000000e-05 9.312145204041e-01
+ 1.526400000000e-05 9.312754996194e-01
+ 1.526500000000e-05 9.313364788346e-01
+ 1.526600000000e-05 9.313974580498e-01
+ 1.526700000000e-05 9.314584372650e-01
+ 1.526800000000e-05 9.315194164802e-01
+ 1.526900000000e-05 9.315803956954e-01
+ 1.527000000000e-05 9.316413749107e-01
+ 1.527100000000e-05 9.317023541259e-01
+ 1.527200000000e-05 9.317633333411e-01
+ 1.527300000000e-05 9.318243125563e-01
+ 1.527400000000e-05 9.318852917715e-01
+ 1.527500000000e-05 9.319462709867e-01
+ 1.527600000000e-05 9.320072502020e-01
+ 1.527700000000e-05 9.320682294172e-01
+ 1.527800000000e-05 9.321292086324e-01
+ 1.527900000000e-05 9.321901878476e-01
+ 1.528000000000e-05 9.322511670628e-01
+ 1.528100000000e-05 9.323121462780e-01
+ 1.528200000000e-05 9.323731254933e-01
+ 1.528300000000e-05 9.324341047085e-01
+ 1.528400000000e-05 9.324950839237e-01
+ 1.528500000000e-05 9.325560631389e-01
+ 1.528600000000e-05 9.326170423541e-01
+ 1.528700000000e-05 9.326780215693e-01
+ 1.528800000000e-05 9.327390007846e-01
+ 1.528900000000e-05 9.327999799998e-01
+ 1.529000000000e-05 9.328609592150e-01
+ 1.529100000000e-05 9.329219384302e-01
+ 1.529200000000e-05 9.329829176454e-01
+ 1.529300000000e-05 9.330438968606e-01
+ 1.529400000000e-05 9.331048760759e-01
+ 1.529500000000e-05 9.331658552911e-01
+ 1.529600000000e-05 9.332268345063e-01
+ 1.529700000000e-05 9.332878137215e-01
+ 1.529800000000e-05 9.333487929367e-01
+ 1.529900000000e-05 9.334097721519e-01
+ 1.530000000000e-05 9.334707513672e-01
+ 1.530100000000e-05 9.335317305824e-01
+ 1.530200000000e-05 9.335927097976e-01
+ 1.530300000000e-05 9.336536890128e-01
+ 1.530400000000e-05 9.337146682280e-01
+ 1.530500000000e-05 9.337756474432e-01
+ 1.530600000000e-05 9.338366266585e-01
+ 1.530700000000e-05 9.338976058737e-01
+ 1.530800000000e-05 9.339585850889e-01
+ 1.530900000000e-05 9.340195643041e-01
+ 1.531000000000e-05 9.340805435193e-01
+ 1.531100000000e-05 9.341415227345e-01
+ 1.531200000000e-05 9.342025019498e-01
+ 1.531300000000e-05 9.342634811650e-01
+ 1.531400000000e-05 9.343244603802e-01
+ 1.531500000000e-05 9.343854395954e-01
+ 1.531600000000e-05 9.344464188106e-01
+ 1.531700000000e-05 9.345073980258e-01
+ 1.531800000000e-05 9.345683772411e-01
+ 1.531900000000e-05 9.346293564563e-01
+ 1.532000000000e-05 9.346903356715e-01
+ 1.532100000000e-05 9.347513148867e-01
+ 1.532200000000e-05 9.348122941019e-01
+ 1.532300000000e-05 9.348732733171e-01
+ 1.532400000000e-05 9.349342525324e-01
+ 1.532500000000e-05 9.349952317476e-01
+ 1.532600000000e-05 9.350562109628e-01
+ 1.532700000000e-05 9.351171901780e-01
+ 1.532800000000e-05 9.351781693932e-01
+ 1.532900000000e-05 9.352391486084e-01
+ 1.533000000000e-05 9.353001278237e-01
+ 1.533100000000e-05 9.353611070389e-01
+ 1.533200000000e-05 9.354220862541e-01
+ 1.533300000000e-05 9.354830654693e-01
+ 1.533400000000e-05 9.355440446845e-01
+ 1.533500000000e-05 9.356050238997e-01
+ 1.533600000000e-05 9.356660031150e-01
+ 1.533700000000e-05 9.357269823302e-01
+ 1.533800000000e-05 9.357879615454e-01
+ 1.533900000000e-05 9.358489407606e-01
+ 1.534000000000e-05 9.359099199758e-01
+ 1.534100000000e-05 9.359708991910e-01
+ 1.534200000000e-05 9.360318784063e-01
+ 1.534300000000e-05 9.360928576215e-01
+ 1.534400000000e-05 9.361538368367e-01
+ 1.534500000000e-05 9.362148160519e-01
+ 1.534600000000e-05 9.362757952671e-01
+ 1.534700000000e-05 9.363367744823e-01
+ 1.534800000000e-05 9.363977536976e-01
+ 1.534900000000e-05 9.364587329128e-01
+ 1.535000000000e-05 9.365197121280e-01
+ 1.535100000000e-05 9.365806913432e-01
+ 1.535200000000e-05 9.366416705584e-01
+ 1.535300000000e-05 9.367026497736e-01
+ 1.535400000000e-05 9.367636289889e-01
+ 1.535500000000e-05 9.368246082041e-01
+ 1.535600000000e-05 9.368855874193e-01
+ 1.535700000000e-05 9.369465666345e-01
+ 1.535800000000e-05 9.370075458497e-01
+ 1.535900000000e-05 9.370685250649e-01
+ 1.536000000000e-05 9.371295042802e-01
+ 1.536100000000e-05 9.371904834954e-01
+ 1.536200000000e-05 9.372514627106e-01
+ 1.536300000000e-05 9.373124419258e-01
+ 1.536400000000e-05 9.373734211410e-01
+ 1.536500000000e-05 9.374344003562e-01
+ 1.536600000000e-05 9.374953795714e-01
+ 1.536700000000e-05 9.375563587867e-01
+ 1.536800000000e-05 9.376173380019e-01
+ 1.536900000000e-05 9.376783172171e-01
+ 1.537000000000e-05 9.377392964323e-01
+ 1.537100000000e-05 9.378002756475e-01
+ 1.537200000000e-05 9.378612548627e-01
+ 1.537300000000e-05 9.379222340780e-01
+ 1.537400000000e-05 9.379832132932e-01
+ 1.537500000000e-05 9.380441925084e-01
+ 1.537600000000e-05 9.381051717236e-01
+ 1.537700000000e-05 9.381661509388e-01
+ 1.537800000000e-05 9.382271301540e-01
+ 1.537900000000e-05 9.382881093693e-01
+ 1.538000000000e-05 9.383490885845e-01
+ 1.538100000000e-05 9.384100677997e-01
+ 1.538200000000e-05 9.384710470149e-01
+ 1.538300000000e-05 9.385320262301e-01
+ 1.538400000000e-05 9.385930054453e-01
+ 1.538500000000e-05 9.386539846606e-01
+ 1.538600000000e-05 9.387149638758e-01
+ 1.538700000000e-05 9.387759430910e-01
+ 1.538800000000e-05 9.388369223062e-01
+ 1.538900000000e-05 9.388979015214e-01
+ 1.539000000000e-05 9.389588807366e-01
+ 1.539100000000e-05 9.390198599519e-01
+ 1.539200000000e-05 9.390808391671e-01
+ 1.539300000000e-05 9.391418183823e-01
+ 1.539400000000e-05 9.392027975975e-01
+ 1.539500000000e-05 9.392637768127e-01
+ 1.539600000000e-05 9.393247560279e-01
+ 1.539700000000e-05 9.393857352432e-01
+ 1.539800000000e-05 9.394467144584e-01
+ 1.539900000000e-05 9.395076936736e-01
+ 1.540000000000e-05 9.395686728888e-01
+ 1.540100000000e-05 9.396296521040e-01
+ 1.540200000000e-05 9.396906313192e-01
+ 1.540300000000e-05 9.397516105345e-01
+ 1.540400000000e-05 9.398125897497e-01
+ 1.540500000000e-05 9.398735689649e-01
+ 1.540600000000e-05 9.399345481801e-01
+ 1.540700000000e-05 9.399955273953e-01
+ 1.540800000000e-05 9.400565066105e-01
+ 1.540900000000e-05 9.401174858258e-01
+ 1.541000000000e-05 9.401784650410e-01
+ 1.541100000000e-05 9.402394442562e-01
+ 1.541200000000e-05 9.403004234714e-01
+ 1.541300000000e-05 9.403614026866e-01
+ 1.541400000000e-05 9.404223819018e-01
+ 1.541500000000e-05 9.404833611171e-01
+ 1.541600000000e-05 9.405443403323e-01
+ 1.541700000000e-05 9.406053195475e-01
+ 1.541800000000e-05 9.406662987627e-01
+ 1.541900000000e-05 9.407272779779e-01
+ 1.542000000000e-05 9.407882571931e-01
+ 1.542100000000e-05 9.408492364084e-01
+ 1.542200000000e-05 9.409102156236e-01
+ 1.542300000000e-05 9.409711948388e-01
+ 1.542400000000e-05 9.410321740540e-01
+ 1.542500000000e-05 9.410931532692e-01
+ 1.542600000000e-05 9.411541324844e-01
+ 1.542700000000e-05 9.412151116997e-01
+ 1.542800000000e-05 9.412760909149e-01
+ 1.542900000000e-05 9.413370701301e-01
+ 1.543000000000e-05 9.413980493453e-01
+ 1.543100000000e-05 9.414590285605e-01
+ 1.543200000000e-05 9.415200077757e-01
+ 1.543300000000e-05 9.415809869910e-01
+ 1.543400000000e-05 9.416419662062e-01
+ 1.543500000000e-05 9.417029454214e-01
+ 1.543600000000e-05 9.417639246366e-01
+ 1.543700000000e-05 9.418249038518e-01
+ 1.543800000000e-05 9.418858830670e-01
+ 1.543900000000e-05 9.419468622823e-01
+ 1.544000000000e-05 9.420078414975e-01
+ 1.544100000000e-05 9.420688207127e-01
+ 1.544200000000e-05 9.421297999279e-01
+ 1.544300000000e-05 9.421907791431e-01
+ 1.544400000000e-05 9.422517583583e-01
+ 1.544500000000e-05 9.423127375736e-01
+ 1.544600000000e-05 9.423737167888e-01
+ 1.544700000000e-05 9.424346960040e-01
+ 1.544800000000e-05 9.424956752192e-01
+ 1.544900000000e-05 9.425566544344e-01
+ 1.545000000000e-05 9.426176336496e-01
+ 1.545100000000e-05 9.426786128649e-01
+ 1.545200000000e-05 9.427395920801e-01
+ 1.545300000000e-05 9.428005712953e-01
+ 1.545400000000e-05 9.428615505105e-01
+ 1.545500000000e-05 9.429225297257e-01
+ 1.545600000000e-05 9.429835089409e-01
+ 1.545700000000e-05 9.430444881562e-01
+ 1.545800000000e-05 9.431054673714e-01
+ 1.545900000000e-05 9.431664465866e-01
+ 1.546000000000e-05 9.432274258018e-01
+ 1.546100000000e-05 9.432884050170e-01
+ 1.546200000000e-05 9.433493842322e-01
+ 1.546300000000e-05 9.434103634475e-01
+ 1.546400000000e-05 9.434713426627e-01
+ 1.546500000000e-05 9.435323218779e-01
+ 1.546600000000e-05 9.435933010931e-01
+ 1.546700000000e-05 9.436542803083e-01
+ 1.546800000000e-05 9.437152595235e-01
+ 1.546900000000e-05 9.437762387388e-01
+ 1.547000000000e-05 9.438372179540e-01
+ 1.547100000000e-05 9.438981971692e-01
+ 1.547200000000e-05 9.439591763844e-01
+ 1.547300000000e-05 9.440201555996e-01
+ 1.547400000000e-05 9.440811348148e-01
+ 1.547500000000e-05 9.441421140301e-01
+ 1.547600000000e-05 9.442030932453e-01
+ 1.547700000000e-05 9.442640724605e-01
+ 1.547800000000e-05 9.443250516757e-01
+ 1.547900000000e-05 9.443860308909e-01
+ 1.548000000000e-05 9.444470101061e-01
+ 1.548100000000e-05 9.445079893214e-01
+ 1.548200000000e-05 9.445689685366e-01
+ 1.548300000000e-05 9.446299477518e-01
+ 1.548400000000e-05 9.446909269670e-01
+ 1.548500000000e-05 9.447519061822e-01
+ 1.548600000000e-05 9.448128853974e-01
+ 1.548700000000e-05 9.448738646127e-01
+ 1.548800000000e-05 9.449348438279e-01
+ 1.548900000000e-05 9.449958230431e-01
+ 1.549000000000e-05 9.450568022583e-01
+ 1.549100000000e-05 9.451177814735e-01
+ 1.549200000000e-05 9.451787606887e-01
+ 1.549300000000e-05 9.452397399040e-01
+ 1.549400000000e-05 9.453007191192e-01
+ 1.549500000000e-05 9.453616983344e-01
+ 1.549600000000e-05 9.454226775496e-01
+ 1.549700000000e-05 9.454836567648e-01
+ 1.549800000000e-05 9.455446359800e-01
+ 1.549900000000e-05 9.456056151953e-01
+ 1.550000000000e-05 9.456665944105e-01
+ 1.550100000000e-05 9.457275736257e-01
+ 1.550200000000e-05 9.457885528409e-01
+ 1.550300000000e-05 9.458495320561e-01
+ 1.550400000000e-05 9.459105112713e-01
+ 1.550500000000e-05 9.459714904866e-01
+ 1.550600000000e-05 9.460324697018e-01
+ 1.550700000000e-05 9.460934489170e-01
+ 1.550800000000e-05 9.461544281322e-01
+ 1.550900000000e-05 9.462154073474e-01
+ 1.551000000000e-05 9.462763865626e-01
+ 1.551100000000e-05 9.463373657779e-01
+ 1.551200000000e-05 9.463983449931e-01
+ 1.551300000000e-05 9.464593242083e-01
+ 1.551400000000e-05 9.465203034235e-01
+ 1.551500000000e-05 9.465812826387e-01
+ 1.551600000000e-05 9.466422618539e-01
+ 1.551700000000e-05 9.467032410692e-01
+ 1.551800000000e-05 9.467642202844e-01
+ 1.551900000000e-05 9.468251994996e-01
+ 1.552000000000e-05 9.468861787148e-01
+ 1.552100000000e-05 9.469471579300e-01
+ 1.552200000000e-05 9.470081371452e-01
+ 1.552300000000e-05 9.470691163605e-01
+ 1.552400000000e-05 9.471300955757e-01
+ 1.552500000000e-05 9.471910747909e-01
+ 1.552600000000e-05 9.472520540061e-01
+ 1.552700000000e-05 9.473130332213e-01
+ 1.552800000000e-05 9.473740124365e-01
+ 1.552900000000e-05 9.474349916518e-01
+ 1.553000000000e-05 9.474959708670e-01
+ 1.553100000000e-05 9.475569500822e-01
+ 1.553200000000e-05 9.476179292974e-01
+ 1.553300000000e-05 9.476789085126e-01
+ 1.553400000000e-05 9.477398877278e-01
+ 1.553500000000e-05 9.478008669431e-01
+ 1.553600000000e-05 9.478618461583e-01
+ 1.553700000000e-05 9.479228253735e-01
+ 1.553800000000e-05 9.479838045887e-01
+ 1.553900000000e-05 9.480447838039e-01
+ 1.554000000000e-05 9.481057630191e-01
+ 1.554100000000e-05 9.481667422344e-01
+ 1.554200000000e-05 9.482277214496e-01
+ 1.554300000000e-05 9.482887006648e-01
+ 1.554400000000e-05 9.483496798800e-01
+ 1.554500000000e-05 9.484106590952e-01
+ 1.554600000000e-05 9.484716383104e-01
+ 1.554700000000e-05 9.485326175257e-01
+ 1.554800000000e-05 9.485935967409e-01
+ 1.554900000000e-05 9.486545759561e-01
+ 1.555000000000e-05 9.487155551713e-01
+ 1.555100000000e-05 9.487765343865e-01
+ 1.555200000000e-05 9.488375136017e-01
+ 1.555300000000e-05 9.488984928170e-01
+ 1.555400000000e-05 9.489594720322e-01
+ 1.555500000000e-05 9.490204512474e-01
+ 1.555600000000e-05 9.490814304626e-01
+ 1.555700000000e-05 9.491424096778e-01
+ 1.555800000000e-05 9.492033888930e-01
+ 1.555900000000e-05 9.492643681083e-01
+ 1.556000000000e-05 9.493253473235e-01
+ 1.556100000000e-05 9.493863265387e-01
+ 1.556200000000e-05 9.494473057539e-01
+ 1.556300000000e-05 9.495082849691e-01
+ 1.556400000000e-05 9.495692641843e-01
+ 1.556500000000e-05 9.496302433996e-01
+ 1.556600000000e-05 9.496912226148e-01
+ 1.556700000000e-05 9.497522018300e-01
+ 1.556800000000e-05 9.498131810452e-01
+ 1.556900000000e-05 9.498741602604e-01
+ 1.557000000000e-05 9.499351394756e-01
+ 1.557100000000e-05 9.499961186909e-01
+ 1.557200000000e-05 9.500570979061e-01
+ 1.557300000000e-05 9.501180771213e-01
+ 1.557400000000e-05 9.501790563365e-01
+ 1.557500000000e-05 9.502400355517e-01
+ 1.557600000000e-05 9.503010147669e-01
+ 1.557700000000e-05 9.503619939822e-01
+ 1.557800000000e-05 9.504229731974e-01
+ 1.557900000000e-05 9.504839524126e-01
+ 1.558000000000e-05 9.505449316278e-01
+ 1.558100000000e-05 9.506059108430e-01
+ 1.558200000000e-05 9.506668900582e-01
+ 1.558300000000e-05 9.507278692735e-01
+ 1.558400000000e-05 9.507888484887e-01
+ 1.558500000000e-05 9.508498277039e-01
+ 1.558600000000e-05 9.509108069191e-01
+ 1.558700000000e-05 9.509717861343e-01
+ 1.558800000000e-05 9.510327653495e-01
+ 1.558900000000e-05 9.510937445648e-01
+ 1.559000000000e-05 9.511547237800e-01
+ 1.559100000000e-05 9.512157029952e-01
+ 1.559200000000e-05 9.512766822104e-01
+ 1.559300000000e-05 9.513376614256e-01
+ 1.559400000000e-05 9.513986406408e-01
+ 1.559500000000e-05 9.514596198560e-01
+ 1.559600000000e-05 9.515205990713e-01
+ 1.559700000000e-05 9.515815782865e-01
+ 1.559800000000e-05 9.516425575017e-01
+ 1.559900000000e-05 9.517035367169e-01
+ 1.560000000000e-05 9.517645159321e-01
+ 1.560100000000e-05 9.518254951473e-01
+ 1.560200000000e-05 9.518864743626e-01
+ 1.560300000000e-05 9.519474535778e-01
+ 1.560400000000e-05 9.520084327930e-01
+ 1.560500000000e-05 9.520694120082e-01
+ 1.560600000000e-05 9.521303912234e-01
+ 1.560700000000e-05 9.521913704386e-01
+ 1.560800000000e-05 9.522523496539e-01
+ 1.560900000000e-05 9.523133288691e-01
+ 1.561000000000e-05 9.523743080843e-01
+ 1.561100000000e-05 9.524352872995e-01
+ 1.561200000000e-05 9.524962665147e-01
+ 1.561300000000e-05 9.525572457299e-01
+ 1.561400000000e-05 9.526182249452e-01
+ 1.561500000000e-05 9.526792041604e-01
+ 1.561600000000e-05 9.527401833756e-01
+ 1.561700000000e-05 9.528011625908e-01
+ 1.561800000000e-05 9.528621418060e-01
+ 1.561900000000e-05 9.529231210212e-01
+ 1.562000000000e-05 9.529841002365e-01
+ 1.562100000000e-05 9.530450794517e-01
+ 1.562200000000e-05 9.531060586669e-01
+ 1.562300000000e-05 9.531670378821e-01
+ 1.562400000000e-05 9.532280170973e-01
+ 1.562500000000e-05 9.532889963125e-01
+ 1.562600000000e-05 9.533499755278e-01
+ 1.562700000000e-05 9.534109547430e-01
+ 1.562800000000e-05 9.534719339582e-01
+ 1.562900000000e-05 9.535329131734e-01
+ 1.563000000000e-05 9.535938923886e-01
+ 1.563100000000e-05 9.536548716038e-01
+ 1.563200000000e-05 9.537158508191e-01
+ 1.563300000000e-05 9.537768300343e-01
+ 1.563400000000e-05 9.538378092495e-01
+ 1.563500000000e-05 9.538987884647e-01
+ 1.563600000000e-05 9.539597676799e-01
+ 1.563700000000e-05 9.540207468951e-01
+ 1.563800000000e-05 9.540817261104e-01
+ 1.563900000000e-05 9.541427053256e-01
+ 1.564000000000e-05 9.542036845408e-01
+ 1.564100000000e-05 9.542646637560e-01
+ 1.564200000000e-05 9.543256429712e-01
+ 1.564300000000e-05 9.543866221864e-01
+ 1.564400000000e-05 9.544476014017e-01
+ 1.564500000000e-05 9.545085806169e-01
+ 1.564600000000e-05 9.545695598321e-01
+ 1.564700000000e-05 9.546305390473e-01
+ 1.564800000000e-05 9.546915182625e-01
+ 1.564900000000e-05 9.547524974777e-01
+ 1.565000000000e-05 9.548134766930e-01
+ 1.565100000000e-05 9.548744559082e-01
+ 1.565200000000e-05 9.549354351234e-01
+ 1.565300000000e-05 9.549964143386e-01
+ 1.565400000000e-05 9.550573935538e-01
+ 1.565500000000e-05 9.551183727690e-01
+ 1.565600000000e-05 9.551793519843e-01
+ 1.565700000000e-05 9.552403311995e-01
+ 1.565800000000e-05 9.553013104147e-01
+ 1.565900000000e-05 9.553622896299e-01
+ 1.566000000000e-05 9.554232688451e-01
+ 1.566100000000e-05 9.554842480603e-01
+ 1.566200000000e-05 9.555452272756e-01
+ 1.566300000000e-05 9.556062064908e-01
+ 1.566400000000e-05 9.556671857060e-01
+ 1.566500000000e-05 9.557281649212e-01
+ 1.566600000000e-05 9.557891441364e-01
+ 1.566700000000e-05 9.558501233516e-01
+ 1.566800000000e-05 9.559111025669e-01
+ 1.566900000000e-05 9.559720817821e-01
+ 1.567000000000e-05 9.560330609973e-01
+ 1.567100000000e-05 9.560940402125e-01
+ 1.567200000000e-05 9.561550194277e-01
+ 1.567300000000e-05 9.562159986429e-01
+ 1.567400000000e-05 9.562769778582e-01
+ 1.567500000000e-05 9.563379570734e-01
+ 1.567600000000e-05 9.563989362886e-01
+ 1.567700000000e-05 9.564599155038e-01
+ 1.567800000000e-05 9.565208947190e-01
+ 1.567900000000e-05 9.565818739342e-01
+ 1.568000000000e-05 9.566428531495e-01
+ 1.568100000000e-05 9.567038323647e-01
+ 1.568200000000e-05 9.567648115799e-01
+ 1.568300000000e-05 9.568257907951e-01
+ 1.568400000000e-05 9.568867700103e-01
+ 1.568500000000e-05 9.569477492255e-01
+ 1.568600000000e-05 9.570087284408e-01
+ 1.568700000000e-05 9.570697076560e-01
+ 1.568800000000e-05 9.571306868712e-01
+ 1.568900000000e-05 9.571916660864e-01
+ 1.569000000000e-05 9.572526453016e-01
+ 1.569100000000e-05 9.573136245168e-01
+ 1.569200000000e-05 9.573746037321e-01
+ 1.569300000000e-05 9.574355829473e-01
+ 1.569400000000e-05 9.574965621625e-01
+ 1.569500000000e-05 9.575575413777e-01
+ 1.569600000000e-05 9.576185205929e-01
+ 1.569700000000e-05 9.576794998081e-01
+ 1.569800000000e-05 9.577404790234e-01
+ 1.569900000000e-05 9.578014582386e-01
+ 1.570000000000e-05 9.578624374538e-01
+ 1.570100000000e-05 9.579234166690e-01
+ 1.570200000000e-05 9.579843958842e-01
+ 1.570300000000e-05 9.580453750994e-01
+ 1.570400000000e-05 9.581063543147e-01
+ 1.570500000000e-05 9.581673335299e-01
+ 1.570600000000e-05 9.582283127451e-01
+ 1.570700000000e-05 9.582892919603e-01
+ 1.570800000000e-05 9.583502711755e-01
+ 1.570900000000e-05 9.584112503907e-01
+ 1.571000000000e-05 9.584722296060e-01
+ 1.571100000000e-05 9.585332088212e-01
+ 1.571200000000e-05 9.585941880364e-01
+ 1.571300000000e-05 9.586551672516e-01
+ 1.571400000000e-05 9.587161464668e-01
+ 1.571500000000e-05 9.587771256820e-01
+ 1.571600000000e-05 9.588381048973e-01
+ 1.571700000000e-05 9.588990841125e-01
+ 1.571800000000e-05 9.589600633277e-01
+ 1.571900000000e-05 9.590210425429e-01
+ 1.572000000000e-05 9.590820217581e-01
+ 1.572100000000e-05 9.591430009733e-01
+ 1.572200000000e-05 9.592039801886e-01
+ 1.572300000000e-05 9.592649594038e-01
+ 1.572400000000e-05 9.593259386190e-01
+ 1.572500000000e-05 9.593869178342e-01
+ 1.572600000000e-05 9.594478970494e-01
+ 1.572700000000e-05 9.595088762646e-01
+ 1.572800000000e-05 9.595698554799e-01
+ 1.572900000000e-05 9.596308346951e-01
+ 1.573000000000e-05 9.596918139103e-01
+ 1.573100000000e-05 9.597527931255e-01
+ 1.573200000000e-05 9.598137723407e-01
+ 1.573300000000e-05 9.598747515559e-01
+ 1.573400000000e-05 9.599357307712e-01
+ 1.573500000000e-05 9.599967099864e-01
+ 1.573600000000e-05 9.600576892016e-01
+ 1.573700000000e-05 9.601186684168e-01
+ 1.573800000000e-05 9.601796476320e-01
+ 1.573900000000e-05 9.602406268472e-01
+ 1.574000000000e-05 9.603016060625e-01
+ 1.574100000000e-05 9.603625852777e-01
+ 1.574200000000e-05 9.604235644929e-01
+ 1.574300000000e-05 9.604845437081e-01
+ 1.574400000000e-05 9.605455229233e-01
+ 1.574500000000e-05 9.606065021385e-01
+ 1.574600000000e-05 9.606674813538e-01
+ 1.574700000000e-05 9.607284605690e-01
+ 1.574800000000e-05 9.607894397842e-01
+ 1.574900000000e-05 9.608504189994e-01
+ 1.575000000000e-05 9.609113982146e-01
+ 1.575100000000e-05 9.609723774298e-01
+ 1.575200000000e-05 9.610333566451e-01
+ 1.575300000000e-05 9.610943358603e-01
+ 1.575400000000e-05 9.611553150755e-01
+ 1.575500000000e-05 9.612162942907e-01
+ 1.575600000000e-05 9.612772735059e-01
+ 1.575700000000e-05 9.613382527211e-01
+ 1.575800000000e-05 9.613992319364e-01
+ 1.575900000000e-05 9.614602111516e-01
+ 1.576000000000e-05 9.615211903668e-01
+ 1.576100000000e-05 9.615821695820e-01
+ 1.576200000000e-05 9.616431487972e-01
+ 1.576300000000e-05 9.617041280124e-01
+ 1.576400000000e-05 9.617651072277e-01
+ 1.576500000000e-05 9.618260864429e-01
+ 1.576600000000e-05 9.618870656581e-01
+ 1.576700000000e-05 9.619480448733e-01
+ 1.576800000000e-05 9.620090240885e-01
+ 1.576900000000e-05 9.620700033037e-01
+ 1.577000000000e-05 9.621309825190e-01
+ 1.577100000000e-05 9.621919617342e-01
+ 1.577200000000e-05 9.622529409494e-01
+ 1.577300000000e-05 9.623139201646e-01
+ 1.577400000000e-05 9.623748993798e-01
+ 1.577500000000e-05 9.624358785950e-01
+ 1.577600000000e-05 9.624968578103e-01
+ 1.577700000000e-05 9.625578370255e-01
+ 1.577800000000e-05 9.626188162407e-01
+ 1.577900000000e-05 9.626797954559e-01
+ 1.578000000000e-05 9.627407746711e-01
+ 1.578100000000e-05 9.628017538863e-01
+ 1.578200000000e-05 9.628627331016e-01
+ 1.578300000000e-05 9.629237123168e-01
+ 1.578400000000e-05 9.629846915320e-01
+ 1.578500000000e-05 9.630456707472e-01
+ 1.578600000000e-05 9.631066499624e-01
+ 1.578700000000e-05 9.631676291776e-01
+ 1.578800000000e-05 9.632286083929e-01
+ 1.578900000000e-05 9.632895876081e-01
+ 1.579000000000e-05 9.633505668233e-01
+ 1.579100000000e-05 9.634115460385e-01
+ 1.579200000000e-05 9.634725252537e-01
+ 1.579300000000e-05 9.635335044689e-01
+ 1.579400000000e-05 9.635944836842e-01
+ 1.579500000000e-05 9.636554628994e-01
+ 1.579600000000e-05 9.637164421146e-01
+ 1.579700000000e-05 9.637774213298e-01
+ 1.579800000000e-05 9.638384005450e-01
+ 1.579900000000e-05 9.638993797602e-01
+ 1.580000000000e-05 9.639603589755e-01
+ 1.580100000000e-05 9.640213381907e-01
+ 1.580200000000e-05 9.640823174059e-01
+ 1.580300000000e-05 9.641432966211e-01
+ 1.580400000000e-05 9.642042758363e-01
+ 1.580500000000e-05 9.642652550515e-01
+ 1.580600000000e-05 9.643262342668e-01
+ 1.580700000000e-05 9.643872134820e-01
+ 1.580800000000e-05 9.644481926972e-01
+ 1.580900000000e-05 9.645091719124e-01
+ 1.581000000000e-05 9.645701511276e-01
+ 1.581100000000e-05 9.646311303428e-01
+ 1.581200000000e-05 9.646921095581e-01
+ 1.581300000000e-05 9.647530887733e-01
+ 1.581400000000e-05 9.648140679885e-01
+ 1.581500000000e-05 9.648750472037e-01
+ 1.581600000000e-05 9.649360264189e-01
+ 1.581700000000e-05 9.649970056341e-01
+ 1.581800000000e-05 9.650579848494e-01
+ 1.581900000000e-05 9.651189640646e-01
+ 1.582000000000e-05 9.651799432798e-01
+ 1.582100000000e-05 9.652409224950e-01
+ 1.582200000000e-05 9.653019017102e-01
+ 1.582300000000e-05 9.653628809254e-01
+ 1.582400000000e-05 9.654238601406e-01
+ 1.582500000000e-05 9.654848393559e-01
+ 1.582600000000e-05 9.655458185711e-01
+ 1.582700000000e-05 9.656067977863e-01
+ 1.582800000000e-05 9.656677770015e-01
+ 1.582900000000e-05 9.657287562167e-01
+ 1.583000000000e-05 9.657897354319e-01
+ 1.583100000000e-05 9.658507146472e-01
+ 1.583200000000e-05 9.659116938624e-01
+ 1.583300000000e-05 9.659726730776e-01
+ 1.583400000000e-05 9.660336522928e-01
+ 1.583500000000e-05 9.660946315080e-01
+ 1.583600000000e-05 9.661556107232e-01
+ 1.583700000000e-05 9.662165899385e-01
+ 1.583800000000e-05 9.662775691537e-01
+ 1.583900000000e-05 9.663385483689e-01
+ 1.584000000000e-05 9.663995275841e-01
+ 1.584100000000e-05 9.664605067993e-01
+ 1.584200000000e-05 9.665214860145e-01
+ 1.584300000000e-05 9.665824652298e-01
+ 1.584400000000e-05 9.666434444450e-01
+ 1.584500000000e-05 9.667044236602e-01
+ 1.584600000000e-05 9.667654028754e-01
+ 1.584700000000e-05 9.668263820906e-01
+ 1.584800000000e-05 9.668873613058e-01
+ 1.584900000000e-05 9.669483405211e-01
+ 1.585000000000e-05 9.670093197363e-01
+ 1.585100000000e-05 9.670702989515e-01
+ 1.585200000000e-05 9.671312781667e-01
+ 1.585300000000e-05 9.671922573819e-01
+ 1.585400000000e-05 9.672532365971e-01
+ 1.585500000000e-05 9.673142158124e-01
+ 1.585600000000e-05 9.673751950276e-01
+ 1.585700000000e-05 9.674361742428e-01
+ 1.585800000000e-05 9.674971534580e-01
+ 1.585900000000e-05 9.675581326732e-01
+ 1.586000000000e-05 9.676191118884e-01
+ 1.586100000000e-05 9.676800911037e-01
+ 1.586200000000e-05 9.677410703189e-01
+ 1.586300000000e-05 9.678020495341e-01
+ 1.586400000000e-05 9.678630287493e-01
+ 1.586500000000e-05 9.679240079645e-01
+ 1.586600000000e-05 9.679849871797e-01
+ 1.586700000000e-05 9.680459663950e-01
+ 1.586800000000e-05 9.681069456102e-01
+ 1.586900000000e-05 9.681679248254e-01
+ 1.587000000000e-05 9.682289040406e-01
+ 1.587100000000e-05 9.682898832558e-01
+ 1.587200000000e-05 9.683508624710e-01
+ 1.587300000000e-05 9.684118416863e-01
+ 1.587400000000e-05 9.684728209015e-01
+ 1.587500000000e-05 9.685338001167e-01
+ 1.587600000000e-05 9.685947793319e-01
+ 1.587700000000e-05 9.686557585471e-01
+ 1.587800000000e-05 9.687167377623e-01
+ 1.587900000000e-05 9.687777169776e-01
+ 1.588000000000e-05 9.688386961928e-01
+ 1.588100000000e-05 9.688996754080e-01
+ 1.588200000000e-05 9.689606546232e-01
+ 1.588300000000e-05 9.690216338384e-01
+ 1.588400000000e-05 9.690826130536e-01
+ 1.588500000000e-05 9.691435922689e-01
+ 1.588600000000e-05 9.692045714841e-01
+ 1.588700000000e-05 9.692655506993e-01
+ 1.588800000000e-05 9.693265299145e-01
+ 1.588900000000e-05 9.693875091297e-01
+ 1.589000000000e-05 9.694484883449e-01
+ 1.589100000000e-05 9.695094675602e-01
+ 1.589200000000e-05 9.695704467754e-01
+ 1.589300000000e-05 9.696314259906e-01
+ 1.589400000000e-05 9.696924052058e-01
+ 1.589500000000e-05 9.697533844210e-01
+ 1.589600000000e-05 9.698143636362e-01
+ 1.589700000000e-05 9.698753428515e-01
+ 1.589800000000e-05 9.699363220667e-01
+ 1.589900000000e-05 9.699973012819e-01
+ 1.590000000000e-05 9.700582804971e-01
+ 1.590100000000e-05 9.701192597123e-01
+ 1.590200000000e-05 9.701802389275e-01
+ 1.590300000000e-05 9.702412181428e-01
+ 1.590400000000e-05 9.703021973580e-01
+ 1.590500000000e-05 9.703631765732e-01
+ 1.590600000000e-05 9.704241557884e-01
+ 1.590700000000e-05 9.704851350036e-01
+ 1.590800000000e-05 9.705461142188e-01
+ 1.590900000000e-05 9.706070934341e-01
+ 1.591000000000e-05 9.706680726493e-01
+ 1.591100000000e-05 9.707290518645e-01
+ 1.591200000000e-05 9.707900310797e-01
+ 1.591300000000e-05 9.708510102949e-01
+ 1.591400000000e-05 9.709119895101e-01
+ 1.591500000000e-05 9.709729687254e-01
+ 1.591600000000e-05 9.710339479406e-01
+ 1.591700000000e-05 9.710949271558e-01
+ 1.591800000000e-05 9.711559063710e-01
+ 1.591900000000e-05 9.712168855862e-01
+ 1.592000000000e-05 9.712778648014e-01
+ 1.592100000000e-05 9.713388440167e-01
+ 1.592200000000e-05 9.713998232319e-01
+ 1.592300000000e-05 9.714608024471e-01
+ 1.592400000000e-05 9.715217816623e-01
+ 1.592500000000e-05 9.715827608775e-01
+ 1.592600000000e-05 9.716437400927e-01
+ 1.592700000000e-05 9.717047193080e-01
+ 1.592800000000e-05 9.717656985232e-01
+ 1.592900000000e-05 9.718266777384e-01
+ 1.593000000000e-05 9.718876569536e-01
+ 1.593100000000e-05 9.719486361688e-01
+ 1.593200000000e-05 9.720096153840e-01
+ 1.593300000000e-05 9.720705945993e-01
+ 1.593400000000e-05 9.721315738145e-01
+ 1.593500000000e-05 9.721925530297e-01
+ 1.593600000000e-05 9.722535322449e-01
+ 1.593700000000e-05 9.723145114601e-01
+ 1.593800000000e-05 9.723754906753e-01
+ 1.593900000000e-05 9.724364698906e-01
+ 1.594000000000e-05 9.724974491058e-01
+ 1.594100000000e-05 9.725584283210e-01
+ 1.594200000000e-05 9.726194075362e-01
+ 1.594300000000e-05 9.726803867514e-01
+ 1.594400000000e-05 9.727413659666e-01
+ 1.594500000000e-05 9.728023451819e-01
+ 1.594600000000e-05 9.728633243971e-01
+ 1.594700000000e-05 9.729243036123e-01
+ 1.594800000000e-05 9.729852828275e-01
+ 1.594900000000e-05 9.730462620427e-01
+ 1.595000000000e-05 9.731072412579e-01
+ 1.595100000000e-05 9.731682204732e-01
+ 1.595200000000e-05 9.732291996884e-01
+ 1.595300000000e-05 9.732901789036e-01
+ 1.595400000000e-05 9.733511581188e-01
+ 1.595500000000e-05 9.734121373340e-01
+ 1.595600000000e-05 9.734731165492e-01
+ 1.595700000000e-05 9.735340957645e-01
+ 1.595800000000e-05 9.735950749797e-01
+ 1.595900000000e-05 9.736560541949e-01
+ 1.596000000000e-05 9.737170334101e-01
+ 1.596100000000e-05 9.737780126253e-01
+ 1.596200000000e-05 9.738389918405e-01
+ 1.596300000000e-05 9.738999710558e-01
+ 1.596400000000e-05 9.739609502710e-01
+ 1.596500000000e-05 9.740219294862e-01
+ 1.596600000000e-05 9.740829087014e-01
+ 1.596700000000e-05 9.741438879166e-01
+ 1.596800000000e-05 9.742048671318e-01
+ 1.596900000000e-05 9.742658463471e-01
+ 1.597000000000e-05 9.743268255623e-01
+ 1.597100000000e-05 9.743878047775e-01
+ 1.597200000000e-05 9.744487839927e-01
+ 1.597300000000e-05 9.745097632079e-01
+ 1.597400000000e-05 9.745707424231e-01
+ 1.597500000000e-05 9.746317216384e-01
+ 1.597600000000e-05 9.746927008536e-01
+ 1.597700000000e-05 9.747536800688e-01
+ 1.597800000000e-05 9.748146592840e-01
+ 1.597900000000e-05 9.748756384992e-01
+ 1.598000000000e-05 9.749366177144e-01
+ 1.598100000000e-05 9.749975969297e-01
+ 1.598200000000e-05 9.750585761449e-01
+ 1.598300000000e-05 9.751195553601e-01
+ 1.598400000000e-05 9.751805345753e-01
+ 1.598500000000e-05 9.752415137905e-01
+ 1.598600000000e-05 9.753024930057e-01
+ 1.598700000000e-05 9.753634722210e-01
+ 1.598800000000e-05 9.754244514362e-01
+ 1.598900000000e-05 9.754854306514e-01
+ 1.599000000000e-05 9.755464098666e-01
+ 1.599100000000e-05 9.756073890818e-01
+ 1.599200000000e-05 9.756683682970e-01
+ 1.599300000000e-05 9.757293475123e-01
+ 1.599400000000e-05 9.757903267275e-01
+ 1.599500000000e-05 9.758513059427e-01
+ 1.599600000000e-05 9.759122851579e-01
+ 1.599700000000e-05 9.759732643731e-01
+ 1.599800000000e-05 9.760342435883e-01
+ 1.599900000000e-05 9.760952228036e-01
+ 1.600000000000e-05 9.761562020188e-01
+ 1.600100000000e-05 9.762171812340e-01
+ 1.600200000000e-05 9.762781604492e-01
+ 1.600300000000e-05 9.763391396644e-01
+ 1.600400000000e-05 9.764001188796e-01
+ 1.600500000000e-05 9.764610980949e-01
+ 1.600600000000e-05 9.765220773101e-01
+ 1.600700000000e-05 9.765830565253e-01
+ 1.600800000000e-05 9.766440357405e-01
+ 1.600900000000e-05 9.767050149557e-01
+ 1.601000000000e-05 9.767659941709e-01
+ 1.601100000000e-05 9.768269733862e-01
+ 1.601200000000e-05 9.768879526014e-01
+ 1.601300000000e-05 9.769489318166e-01
+ 1.601400000000e-05 9.770099110318e-01
+ 1.601500000000e-05 9.770708902470e-01
+ 1.601600000000e-05 9.771318694622e-01
+ 1.601700000000e-05 9.771928486775e-01
+ 1.601800000000e-05 9.772538278927e-01
+ 1.601900000000e-05 9.773148071079e-01
+ 1.602000000000e-05 9.773757863231e-01
+ 1.602100000000e-05 9.774367655383e-01
+ 1.602200000000e-05 9.774977447535e-01
+ 1.602300000000e-05 9.775587239688e-01
+ 1.602400000000e-05 9.776197031840e-01
+ 1.602500000000e-05 9.776806823992e-01
+ 1.602600000000e-05 9.777416616144e-01
+ 1.602700000000e-05 9.778026408296e-01
+ 1.602800000000e-05 9.778636200448e-01
+ 1.602900000000e-05 9.779245992601e-01
+ 1.603000000000e-05 9.779855784753e-01
+ 1.603100000000e-05 9.780465576905e-01
+ 1.603200000000e-05 9.781075369057e-01
+ 1.603300000000e-05 9.781685161209e-01
+ 1.603400000000e-05 9.782294953361e-01
+ 1.603500000000e-05 9.782904745514e-01
+ 1.603600000000e-05 9.783514537666e-01
+ 1.603700000000e-05 9.784124329818e-01
+ 1.603800000000e-05 9.784734121970e-01
+ 1.603900000000e-05 9.785343914122e-01
+ 1.604000000000e-05 9.785953706274e-01
+ 1.604100000000e-05 9.786563498427e-01
+ 1.604200000000e-05 9.787173290579e-01
+ 1.604300000000e-05 9.787783082731e-01
+ 1.604400000000e-05 9.788392874883e-01
+ 1.604500000000e-05 9.789002667035e-01
+ 1.604600000000e-05 9.789612459187e-01
+ 1.604700000000e-05 9.790222251339e-01
+ 1.604800000000e-05 9.790832043492e-01
+ 1.604900000000e-05 9.791441835644e-01
+ 1.605000000000e-05 9.792051627796e-01
+ 1.605100000000e-05 9.792661419948e-01
+ 1.605200000000e-05 9.793271212100e-01
+ 1.605300000000e-05 9.793881004252e-01
+ 1.605400000000e-05 9.794490796405e-01
+ 1.605500000000e-05 9.795100588557e-01
+ 1.605600000000e-05 9.795710380709e-01
+ 1.605700000000e-05 9.796320172861e-01
+ 1.605800000000e-05 9.796929965013e-01
+ 1.605900000000e-05 9.797539757165e-01
+ 1.606000000000e-05 9.798149549318e-01
+ 1.606100000000e-05 9.798759341470e-01
+ 1.606200000000e-05 9.799369133622e-01
+ 1.606300000000e-05 9.799978925774e-01
+ 1.606400000000e-05 9.800588717926e-01
+ 1.606500000000e-05 9.801198510078e-01
+ 1.606600000000e-05 9.801808302231e-01
+ 1.606700000000e-05 9.802418094383e-01
+ 1.606800000000e-05 9.803027886535e-01
+ 1.606900000000e-05 9.803637678687e-01
+ 1.607000000000e-05 9.804247470839e-01
+ 1.607100000000e-05 9.804857262991e-01
+ 1.607200000000e-05 9.805467055144e-01
+ 1.607300000000e-05 9.806076847296e-01
+ 1.607400000000e-05 9.806686639448e-01
+ 1.607500000000e-05 9.807296431600e-01
+ 1.607600000000e-05 9.807906223752e-01
+ 1.607700000000e-05 9.808516015904e-01
+ 1.607800000000e-05 9.809125808057e-01
+ 1.607900000000e-05 9.809735600209e-01
+ 1.608000000000e-05 9.810345392361e-01
+ 1.608100000000e-05 9.810955184513e-01
+ 1.608200000000e-05 9.811564976665e-01
+ 1.608300000000e-05 9.812174768817e-01
+ 1.608400000000e-05 9.812784560970e-01
+ 1.608500000000e-05 9.813394353122e-01
+ 1.608600000000e-05 9.814004145274e-01
+ 1.608700000000e-05 9.814613937426e-01
+ 1.608800000000e-05 9.815223729578e-01
+ 1.608900000000e-05 9.815833521730e-01
+ 1.609000000000e-05 9.816443313883e-01
+ 1.609100000000e-05 9.817053106035e-01
+ 1.609200000000e-05 9.817662898187e-01
+ 1.609300000000e-05 9.818272690339e-01
+ 1.609400000000e-05 9.818882482491e-01
+ 1.609500000000e-05 9.819492274643e-01
+ 1.609600000000e-05 9.820102066796e-01
+ 1.609700000000e-05 9.820711858948e-01
+ 1.609800000000e-05 9.821321651100e-01
+ 1.609900000000e-05 9.821931443252e-01
+ 1.610000000000e-05 9.822541235404e-01
+ 1.610100000000e-05 9.823151027556e-01
+ 1.610200000000e-05 9.823760819709e-01
+ 1.610300000000e-05 9.824370611861e-01
+ 1.610400000000e-05 9.824980404013e-01
+ 1.610500000000e-05 9.825590196165e-01
+ 1.610600000000e-05 9.826199988317e-01
+ 1.610700000000e-05 9.826809780469e-01
+ 1.610800000000e-05 9.827419572622e-01
+ 1.610900000000e-05 9.828029364774e-01
+ 1.611000000000e-05 9.828639156926e-01
+ 1.611100000000e-05 9.829248949078e-01
+ 1.611200000000e-05 9.829858741230e-01
+ 1.611300000000e-05 9.830468533382e-01
+ 1.611400000000e-05 9.831078325535e-01
+ 1.611500000000e-05 9.831688117687e-01
+ 1.611600000000e-05 9.832297909839e-01
+ 1.611700000000e-05 9.832907701991e-01
+ 1.611800000000e-05 9.833517494143e-01
+ 1.611900000000e-05 9.834127286295e-01
+ 1.612000000000e-05 9.834737078448e-01
+ 1.612100000000e-05 9.835346870600e-01
+ 1.612200000000e-05 9.835956662752e-01
+ 1.612300000000e-05 9.836566454904e-01
+ 1.612400000000e-05 9.837176247056e-01
+ 1.612500000000e-05 9.837786039208e-01
+ 1.612600000000e-05 9.838395831361e-01
+ 1.612700000000e-05 9.839005623513e-01
+ 1.612800000000e-05 9.839615415665e-01
+ 1.612900000000e-05 9.840225207817e-01
+ 1.613000000000e-05 9.840834999969e-01
+ 1.613100000000e-05 9.841444792121e-01
+ 1.613200000000e-05 9.842054584274e-01
+ 1.613300000000e-05 9.842664376426e-01
+ 1.613400000000e-05 9.843274168578e-01
+ 1.613500000000e-05 9.843883960730e-01
+ 1.613600000000e-05 9.844493752882e-01
+ 1.613700000000e-05 9.845103545034e-01
+ 1.613800000000e-05 9.845713337187e-01
+ 1.613900000000e-05 9.846323129339e-01
+ 1.614000000000e-05 9.846932921491e-01
+ 1.614100000000e-05 9.847542713643e-01
+ 1.614200000000e-05 9.848152505795e-01
+ 1.614300000000e-05 9.848762297947e-01
+ 1.614400000000e-05 9.849372090100e-01
+ 1.614500000000e-05 9.849981882252e-01
+ 1.614600000000e-05 9.850591674404e-01
+ 1.614700000000e-05 9.851201466556e-01
+ 1.614800000000e-05 9.851811258708e-01
+ 1.614900000000e-05 9.852421050860e-01
+ 1.615000000000e-05 9.853030843013e-01
+ 1.615100000000e-05 9.853640635165e-01
+ 1.615200000000e-05 9.854250427317e-01
+ 1.615300000000e-05 9.854860219469e-01
+ 1.615400000000e-05 9.855470011621e-01
+ 1.615500000000e-05 9.856079803773e-01
+ 1.615600000000e-05 9.856689595926e-01
+ 1.615700000000e-05 9.857299388078e-01
+ 1.615800000000e-05 9.857909180230e-01
+ 1.615900000000e-05 9.858518972382e-01
+ 1.616000000000e-05 9.859128764534e-01
+ 1.616100000000e-05 9.859738556686e-01
+ 1.616200000000e-05 9.860348348839e-01
+ 1.616300000000e-05 9.860958140991e-01
+ 1.616400000000e-05 9.861567933143e-01
+ 1.616500000000e-05 9.862177725295e-01
+ 1.616600000000e-05 9.862787517447e-01
+ 1.616700000000e-05 9.863397309599e-01
+ 1.616800000000e-05 9.864007101752e-01
+ 1.616900000000e-05 9.864616893904e-01
+ 1.617000000000e-05 9.865226686056e-01
+ 1.617100000000e-05 9.865836478208e-01
+ 1.617200000000e-05 9.866446270360e-01
+ 1.617300000000e-05 9.867056062512e-01
+ 1.617400000000e-05 9.867665854665e-01
+ 1.617500000000e-05 9.868275646817e-01
+ 1.617600000000e-05 9.868885438969e-01
+ 1.617700000000e-05 9.869495231121e-01
+ 1.617800000000e-05 9.870105023273e-01
+ 1.617900000000e-05 9.870714815425e-01
+ 1.618000000000e-05 9.871324607578e-01
+ 1.618100000000e-05 9.871934399730e-01
+ 1.618200000000e-05 9.872544191882e-01
+ 1.618300000000e-05 9.873153984034e-01
+ 1.618400000000e-05 9.873763776186e-01
+ 1.618500000000e-05 9.874373568338e-01
+ 1.618600000000e-05 9.874983360491e-01
+ 1.618700000000e-05 9.875593152643e-01
+ 1.618800000000e-05 9.876202944795e-01
+ 1.618900000000e-05 9.876812736947e-01
+ 1.619000000000e-05 9.877422529099e-01
+ 1.619100000000e-05 9.878032321251e-01
+ 1.619200000000e-05 9.878642113404e-01
+ 1.619300000000e-05 9.879251905556e-01
+ 1.619400000000e-05 9.879861697708e-01
+ 1.619500000000e-05 9.880471489860e-01
+ 1.619600000000e-05 9.881081282012e-01
+ 1.619700000000e-05 9.881691074164e-01
+ 1.619800000000e-05 9.882300866317e-01
+ 1.619900000000e-05 9.882910658469e-01
+ 1.620000000000e-05 9.883520450621e-01
+ 1.620100000000e-05 9.884130242773e-01
+ 1.620200000000e-05 9.884740034925e-01
+ 1.620300000000e-05 9.885349827077e-01
+ 1.620400000000e-05 9.885959619230e-01
+ 1.620500000000e-05 9.886569411382e-01
+ 1.620600000000e-05 9.887179203534e-01
+ 1.620700000000e-05 9.887788995686e-01
+ 1.620800000000e-05 9.888398787838e-01
+ 1.620900000000e-05 9.889008579990e-01
+ 1.621000000000e-05 9.889618372143e-01
+ 1.621100000000e-05 9.890228164295e-01
+ 1.621200000000e-05 9.890837956447e-01
+ 1.621300000000e-05 9.891447748599e-01
+ 1.621400000000e-05 9.892057540751e-01
+ 1.621500000000e-05 9.892667332903e-01
+ 1.621600000000e-05 9.893277125056e-01
+ 1.621700000000e-05 9.893886917208e-01
+ 1.621800000000e-05 9.894496709360e-01
+ 1.621900000000e-05 9.895106501512e-01
+ 1.622000000000e-05 9.895716293664e-01
+ 1.622100000000e-05 9.896326085816e-01
+ 1.622200000000e-05 9.896935877969e-01
+ 1.622300000000e-05 9.897545670121e-01
+ 1.622400000000e-05 9.898155462273e-01
+ 1.622500000000e-05 9.898765254425e-01
+ 1.622600000000e-05 9.899375046577e-01
+ 1.622700000000e-05 9.899984838729e-01
+ 1.622800000000e-05 9.900594630882e-01
+ 1.622900000000e-05 9.901204423034e-01
+ 1.623000000000e-05 9.901814215186e-01
+ 1.623100000000e-05 9.902424007338e-01
+ 1.623200000000e-05 9.903033799490e-01
+ 1.623300000000e-05 9.903643591642e-01
+ 1.623400000000e-05 9.904253383795e-01
+ 1.623500000000e-05 9.904863175947e-01
+ 1.623600000000e-05 9.905472968099e-01
+ 1.623700000000e-05 9.906082760251e-01
+ 1.623800000000e-05 9.906692552403e-01
+ 1.623900000000e-05 9.907302344555e-01
+ 1.624000000000e-05 9.907912136708e-01
+ 1.624100000000e-05 9.908521928860e-01
+ 1.624200000000e-05 9.909131721012e-01
+ 1.624300000000e-05 9.909741513164e-01
+ 1.624400000000e-05 9.910351305316e-01
+ 1.624500000000e-05 9.910961097468e-01
+ 1.624600000000e-05 9.911570889621e-01
+ 1.624700000000e-05 9.912180681773e-01
+ 1.624800000000e-05 9.912790473925e-01
+ 1.624900000000e-05 9.913400266077e-01
+ 1.625000000000e-05 9.914010058229e-01
+ 1.625100000000e-05 9.914619850381e-01
+ 1.625200000000e-05 9.915229642534e-01
+ 1.625300000000e-05 9.915839434686e-01
+ 1.625400000000e-05 9.916449226838e-01
+ 1.625500000000e-05 9.917059018990e-01
+ 1.625600000000e-05 9.917668811142e-01
+ 1.625700000000e-05 9.918278603294e-01
+ 1.625800000000e-05 9.918888395447e-01
+ 1.625900000000e-05 9.919498187599e-01
+ 1.626000000000e-05 9.920107979751e-01
+ 1.626100000000e-05 9.920717771903e-01
+ 1.626200000000e-05 9.921327564055e-01
+ 1.626300000000e-05 9.921937356207e-01
+ 1.626400000000e-05 9.922547148360e-01
+ 1.626500000000e-05 9.923156940512e-01
+ 1.626600000000e-05 9.923766732664e-01
+ 1.626700000000e-05 9.924376524816e-01
+ 1.626800000000e-05 9.924986316968e-01
+ 1.626900000000e-05 9.925596109120e-01
+ 1.627000000000e-05 9.926205901273e-01
+ 1.627100000000e-05 9.926815693425e-01
+ 1.627200000000e-05 9.927425485577e-01
+ 1.627300000000e-05 9.928035277729e-01
+ 1.627400000000e-05 9.928645069881e-01
+ 1.627500000000e-05 9.929254862033e-01
+ 1.627600000000e-05 9.929864654185e-01
+ 1.627700000000e-05 9.930474446338e-01
+ 1.627800000000e-05 9.931084238490e-01
+ 1.627900000000e-05 9.931694030642e-01
+ 1.628000000000e-05 9.932303822794e-01
+ 1.628100000000e-05 9.932913614946e-01
+ 1.628200000000e-05 9.933523407098e-01
+ 1.628300000000e-05 9.934133199251e-01
+ 1.628400000000e-05 9.934742991403e-01
+ 1.628500000000e-05 9.935352783555e-01
+ 1.628600000000e-05 9.935962575707e-01
+ 1.628700000000e-05 9.936572367859e-01
+ 1.628800000000e-05 9.937182160011e-01
+ 1.628900000000e-05 9.937791952164e-01
+ 1.629000000000e-05 9.938401744316e-01
+ 1.629100000000e-05 9.939011536468e-01
+ 1.629200000000e-05 9.939621328620e-01
+ 1.629300000000e-05 9.940231120772e-01
+ 1.629400000000e-05 9.940840912924e-01
+ 1.629500000000e-05 9.941450705077e-01
+ 1.629600000000e-05 9.942060497229e-01
+ 1.629700000000e-05 9.942670289381e-01
+ 1.629800000000e-05 9.943280081533e-01
+ 1.629900000000e-05 9.943889873685e-01
+ 1.630000000000e-05 9.944499665837e-01
+ 1.630100000000e-05 9.945109457990e-01
+ 1.630200000000e-05 9.945719250142e-01
+ 1.630300000000e-05 9.946329042294e-01
+ 1.630400000000e-05 9.946938834446e-01
+ 1.630500000000e-05 9.947548626598e-01
+ 1.630600000000e-05 9.948158418750e-01
+ 1.630700000000e-05 9.948768210903e-01
+ 1.630800000000e-05 9.949378003055e-01
+ 1.630900000000e-05 9.949987795207e-01
+ 1.631000000000e-05 9.950597587359e-01
+ 1.631100000000e-05 9.951207379511e-01
+ 1.631200000000e-05 9.951817171663e-01
+ 1.631300000000e-05 9.952426963816e-01
+ 1.631400000000e-05 9.953036755968e-01
+ 1.631500000000e-05 9.953646548120e-01
+ 1.631600000000e-05 9.954256340272e-01
+ 1.631700000000e-05 9.954866132424e-01
+ 1.631800000000e-05 9.955475924576e-01
+ 1.631900000000e-05 9.956085716729e-01
+ 1.632000000000e-05 9.956695508881e-01
+ 1.632100000000e-05 9.957305301033e-01
+ 1.632200000000e-05 9.957915093185e-01
+ 1.632300000000e-05 9.958524885337e-01
+ 1.632400000000e-05 9.959134677489e-01
+ 1.632500000000e-05 9.959744469642e-01
+ 1.632600000000e-05 9.960354261794e-01
+ 1.632700000000e-05 9.960964053946e-01
+ 1.632800000000e-05 9.961573846098e-01
+ 1.632900000000e-05 9.962183638250e-01
+ 1.633000000000e-05 9.962793430402e-01
+ 1.633100000000e-05 9.963403222555e-01
+ 1.633200000000e-05 9.964013014707e-01
+ 1.633300000000e-05 9.964622806859e-01
+ 1.633400000000e-05 9.965232599011e-01
+ 1.633500000000e-05 9.965842391163e-01
+ 1.633600000000e-05 9.966452183315e-01
+ 1.633700000000e-05 9.967061975468e-01
+ 1.633800000000e-05 9.967671767620e-01
+ 1.633900000000e-05 9.968281559772e-01
+ 1.634000000000e-05 9.968891351924e-01
+ 1.634100000000e-05 9.969501144076e-01
+ 1.634200000000e-05 9.970110936228e-01
+ 1.634300000000e-05 9.970720728381e-01
+ 1.634400000000e-05 9.971330520533e-01
+ 1.634500000000e-05 9.971940312685e-01
+ 1.634600000000e-05 9.972550104837e-01
+ 1.634700000000e-05 9.973159896989e-01
+ 1.634800000000e-05 9.973769689141e-01
+ 1.634900000000e-05 9.974379481294e-01
+ 1.635000000000e-05 9.974989273446e-01
+ 1.635100000000e-05 9.975599065598e-01
+ 1.635200000000e-05 9.976208857750e-01
+ 1.635300000000e-05 9.976818649902e-01
+ 1.635400000000e-05 9.977428442054e-01
+ 1.635500000000e-05 9.978038234207e-01
+ 1.635600000000e-05 9.978648026359e-01
+ 1.635700000000e-05 9.979257818511e-01
+ 1.635800000000e-05 9.979867610663e-01
+ 1.635900000000e-05 9.980477402815e-01
+ 1.636000000000e-05 9.981087194967e-01
+ 1.636100000000e-05 9.981696987120e-01
+ 1.636200000000e-05 9.982306779272e-01
+ 1.636300000000e-05 9.982916571424e-01
+ 1.636400000000e-05 9.983526363576e-01
+ 1.636500000000e-05 9.984136155728e-01
+ 1.636600000000e-05 9.984745947880e-01
+ 1.636700000000e-05 9.985355740033e-01
+ 1.636800000000e-05 9.985965532185e-01
+ 1.636900000000e-05 9.986575324337e-01
+ 1.637000000000e-05 9.987185116489e-01
+ 1.637100000000e-05 9.987794908641e-01
+ 1.637200000000e-05 9.988404700793e-01
+ 1.637300000000e-05 9.989014492946e-01
+ 1.637400000000e-05 9.989624285098e-01
+ 1.637500000000e-05 9.990234077250e-01
+ 1.637600000000e-05 9.990843869402e-01
+ 1.637700000000e-05 9.991453661554e-01
+ 1.637800000000e-05 9.992063453706e-01
+ 1.637900000000e-05 9.992673245859e-01
+ 1.638000000000e-05 9.993283038011e-01
+ 1.638100000000e-05 9.993892830163e-01
+ 1.638200000000e-05 9.994502622315e-01
+ 1.638300000000e-05 9.995112414467e-01
+ )
Vclk0 clk0 0 PULSE(0 1 -7.500000000000e-11 100p 100p 2.000000000000e-09 4.000000000000e-09)
Bgain0 v_gain0 0 V={ 9.850000000000e-01*V(vin)+-7.500000000000e-03 }
Bnonlin0 v_nl0 0 V={ V(v_gain0) + VFS*(NONLINEARITY_A2*pow((V(v_gain0)-VCM)/VFS,2) + NONLINEARITY_A3*pow((V(v_gain0)-VCM)/VFS,3)) }
Vclk1 clk1 0 PULSE(0 1 9.750000000000e-10 100p 100p 2.000000000000e-09 4.000000000000e-09)
Bgain1 v_gain1 0 V={ 9.950000000000e-01*V(vin)+-2.500000000000e-03 }
Bnonlin1 v_nl1 0 V={ V(v_gain1) + VFS*(NONLINEARITY_A2*pow((V(v_gain1)-VCM)/VFS,2) + NONLINEARITY_A3*pow((V(v_gain1)-VCM)/VFS,3)) }
Vclk2 clk2 0 PULSE(0 1 2.025000000000e-09 100p 100p 2.000000000000e-09 4.000000000000e-09)
Bgain2 v_gain2 0 V={ 1.005000000000e+00*V(vin)+2.500000000000e-03 }
Bnonlin2 v_nl2 0 V={ V(v_gain2) + VFS*(NONLINEARITY_A2*pow((V(v_gain2)-VCM)/VFS,2) + NONLINEARITY_A3*pow((V(v_gain2)-VCM)/VFS,3)) }
Vclk3 clk3 0 PULSE(0 1 3.075000000000e-09 100p 100p 2.000000000000e-09 4.000000000000e-09)
Bgain3 v_gain3 0 V={ 1.015000000000e+00*V(vin)+7.500000000000e-03 }
Bnonlin3 v_nl3 0 V={ V(v_gain3) + VFS*(NONLINEARITY_A2*pow((V(v_gain3)-VCM)/VFS,2) + NONLINEARITY_A3*pow((V(v_gain3)-VCM)/VFS,3)) }

.control
tran 1.000000000000e-09 1.638400000000e-05
set wr_singlescale
wrdata /home/yongfu/proj/ti-adc-model/outputs/ngspice/combined/logs/ti_static_inl_dnl.wrdata v(vin) v(clk0) v(v_nl0) v(clk1) v(v_nl1) v(clk2) v(v_nl2) v(clk3) v(v_nl3)
.endc
.end
