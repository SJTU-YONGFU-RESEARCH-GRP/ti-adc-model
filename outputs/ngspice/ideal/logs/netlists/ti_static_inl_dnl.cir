* TI static INL/DNL testbench (ngspice behavioral, channel-wise E2E + TI mux)
* Reference: veriloga/ti_channel_adc.va + ti_adc Python golden model
.param BITS=10
.param VREFP=1.0
.param VREFN=0.0
.param MAXCODE=1023
.param LSB=(1.0-0.0)/1023
.param VCM=0.5
.param VFS=1.0
.param FS=1000000000.0
.param NUM_CHANNELS=4
.param SIGMA_THERMAL=0.0
.param NONLINEARITY_A2=0.0
.param NONLINEARITY_A3=0.0
.param JITTER_RMS=0.0
.param DNL_SIGMA_LSB=0.0
.param NOISE_SEED=1
.param SAMPLES_PER_CODE=4
.param NUM_SAMPLES=4096
.param DT=1.000000000000e-09
.param TSTOP=4.096000000000e-06

.options delmax=1.000000000000e-09 maxstep=1.000000000000e-09
Vin vin 0 PWL(
+ 0.000000000000e+00 4.887585532747e-04
+ 1.000000000000e-09 7.327200875588e-04
+ 2.000000000000e-09 9.766816218429e-04
+ 3.000000000000e-09 1.220643156127e-03
+ 4.000000000000e-09 1.464604690411e-03
+ 5.000000000000e-09 1.708566224695e-03
+ 6.000000000000e-09 1.952527758979e-03
+ 7.000000000000e-09 2.196489293263e-03
+ 8.000000000000e-09 2.440450827548e-03
+ 9.000000000000e-09 2.684412361832e-03
+ 1.000000000000e-08 2.928373896116e-03
+ 1.100000000000e-08 3.172335430400e-03
+ 1.200000000000e-08 3.416296964684e-03
+ 1.300000000000e-08 3.660258498968e-03
+ 1.400000000000e-08 3.904220033252e-03
+ 1.500000000000e-08 4.148181567536e-03
+ 1.600000000000e-08 4.392143101821e-03
+ 1.700000000000e-08 4.636104636105e-03
+ 1.800000000000e-08 4.880066170389e-03
+ 1.900000000000e-08 5.124027704673e-03
+ 2.000000000000e-08 5.367989238957e-03
+ 2.100000000000e-08 5.611950773241e-03
+ 2.200000000000e-08 5.855912307525e-03
+ 2.300000000000e-08 6.099873841809e-03
+ 2.400000000000e-08 6.343835376093e-03
+ 2.500000000000e-08 6.587796910378e-03
+ 2.600000000000e-08 6.831758444662e-03
+ 2.700000000000e-08 7.075719978946e-03
+ 2.800000000000e-08 7.319681513230e-03
+ 2.900000000000e-08 7.563643047514e-03
+ 3.000000000000e-08 7.807604581798e-03
+ 3.100000000000e-08 8.051566116082e-03
+ 3.200000000000e-08 8.295527650366e-03
+ 3.300000000000e-08 8.539489184650e-03
+ 3.400000000000e-08 8.783450718935e-03
+ 3.500000000000e-08 9.027412253219e-03
+ 3.600000000000e-08 9.271373787503e-03
+ 3.700000000000e-08 9.515335321787e-03
+ 3.800000000000e-08 9.759296856071e-03
+ 3.900000000000e-08 1.000325839036e-02
+ 4.000000000000e-08 1.024721992464e-02
+ 4.100000000000e-08 1.049118145892e-02
+ 4.200000000000e-08 1.073514299321e-02
+ 4.300000000000e-08 1.097910452749e-02
+ 4.400000000000e-08 1.122306606178e-02
+ 4.500000000000e-08 1.146702759606e-02
+ 4.600000000000e-08 1.171098913034e-02
+ 4.700000000000e-08 1.195495066463e-02
+ 4.800000000000e-08 1.219891219891e-02
+ 4.900000000000e-08 1.244287373320e-02
+ 5.000000000000e-08 1.268683526748e-02
+ 5.100000000000e-08 1.293079680176e-02
+ 5.200000000000e-08 1.317475833605e-02
+ 5.300000000000e-08 1.341871987033e-02
+ 5.400000000000e-08 1.366268140462e-02
+ 5.500000000000e-08 1.390664293890e-02
+ 5.600000000000e-08 1.415060447319e-02
+ 5.700000000000e-08 1.439456600747e-02
+ 5.800000000000e-08 1.463852754175e-02
+ 5.900000000000e-08 1.488248907604e-02
+ 6.000000000000e-08 1.512645061032e-02
+ 6.100000000000e-08 1.537041214461e-02
+ 6.200000000000e-08 1.561437367889e-02
+ 6.300000000000e-08 1.585833521317e-02
+ 6.400000000000e-08 1.610229674746e-02
+ 6.500000000000e-08 1.634625828174e-02
+ 6.600000000000e-08 1.659021981603e-02
+ 6.700000000000e-08 1.683418135031e-02
+ 6.800000000000e-08 1.707814288459e-02
+ 6.900000000000e-08 1.732210441888e-02
+ 7.000000000000e-08 1.756606595316e-02
+ 7.100000000000e-08 1.781002748745e-02
+ 7.200000000000e-08 1.805398902173e-02
+ 7.300000000000e-08 1.829795055602e-02
+ 7.400000000000e-08 1.854191209030e-02
+ 7.500000000000e-08 1.878587362458e-02
+ 7.600000000000e-08 1.902983515887e-02
+ 7.700000000000e-08 1.927379669315e-02
+ 7.800000000000e-08 1.951775822744e-02
+ 7.900000000000e-08 1.976171976172e-02
+ 8.000000000000e-08 2.000568129600e-02
+ 8.100000000000e-08 2.024964283029e-02
+ 8.200000000000e-08 2.049360436457e-02
+ 8.300000000000e-08 2.073756589886e-02
+ 8.400000000000e-08 2.098152743314e-02
+ 8.500000000000e-08 2.122548896742e-02
+ 8.600000000000e-08 2.146945050171e-02
+ 8.700000000000e-08 2.171341203599e-02
+ 8.800000000000e-08 2.195737357028e-02
+ 8.900000000000e-08 2.220133510456e-02
+ 9.000000000000e-08 2.244529663885e-02
+ 9.100000000000e-08 2.268925817313e-02
+ 9.200000000000e-08 2.293321970741e-02
+ 9.300000000000e-08 2.317718124170e-02
+ 9.400000000000e-08 2.342114277598e-02
+ 9.500000000000e-08 2.366510431027e-02
+ 9.600000000000e-08 2.390906584455e-02
+ 9.700000000000e-08 2.415302737883e-02
+ 9.800000000000e-08 2.439698891312e-02
+ 9.900000000000e-08 2.464095044740e-02
+ 1.000000000000e-07 2.488491198169e-02
+ 1.010000000000e-07 2.512887351597e-02
+ 1.020000000000e-07 2.537283505025e-02
+ 1.030000000000e-07 2.561679658454e-02
+ 1.040000000000e-07 2.586075811882e-02
+ 1.050000000000e-07 2.610471965311e-02
+ 1.060000000000e-07 2.634868118739e-02
+ 1.070000000000e-07 2.659264272167e-02
+ 1.080000000000e-07 2.683660425596e-02
+ 1.090000000000e-07 2.708056579024e-02
+ 1.100000000000e-07 2.732452732453e-02
+ 1.110000000000e-07 2.756848885881e-02
+ 1.120000000000e-07 2.781245039310e-02
+ 1.130000000000e-07 2.805641192738e-02
+ 1.140000000000e-07 2.830037346166e-02
+ 1.150000000000e-07 2.854433499595e-02
+ 1.160000000000e-07 2.878829653023e-02
+ 1.170000000000e-07 2.903225806452e-02
+ 1.180000000000e-07 2.927621959880e-02
+ 1.190000000000e-07 2.952018113308e-02
+ 1.200000000000e-07 2.976414266737e-02
+ 1.210000000000e-07 3.000810420165e-02
+ 1.220000000000e-07 3.025206573594e-02
+ 1.230000000000e-07 3.049602727022e-02
+ 1.240000000000e-07 3.073998880450e-02
+ 1.250000000000e-07 3.098395033879e-02
+ 1.260000000000e-07 3.122791187307e-02
+ 1.270000000000e-07 3.147187340736e-02
+ 1.280000000000e-07 3.171583494164e-02
+ 1.290000000000e-07 3.195979647593e-02
+ 1.300000000000e-07 3.220375801021e-02
+ 1.310000000000e-07 3.244771954449e-02
+ 1.320000000000e-07 3.269168107878e-02
+ 1.330000000000e-07 3.293564261306e-02
+ 1.340000000000e-07 3.317960414735e-02
+ 1.350000000000e-07 3.342356568163e-02
+ 1.360000000000e-07 3.366752721591e-02
+ 1.370000000000e-07 3.391148875020e-02
+ 1.380000000000e-07 3.415545028448e-02
+ 1.390000000000e-07 3.439941181877e-02
+ 1.400000000000e-07 3.464337335305e-02
+ 1.410000000000e-07 3.488733488733e-02
+ 1.420000000000e-07 3.513129642162e-02
+ 1.430000000000e-07 3.537525795590e-02
+ 1.440000000000e-07 3.561921949019e-02
+ 1.450000000000e-07 3.586318102447e-02
+ 1.460000000000e-07 3.610714255876e-02
+ 1.470000000000e-07 3.635110409304e-02
+ 1.480000000000e-07 3.659506562732e-02
+ 1.490000000000e-07 3.683902716161e-02
+ 1.500000000000e-07 3.708298869589e-02
+ 1.510000000000e-07 3.732695023018e-02
+ 1.520000000000e-07 3.757091176446e-02
+ 1.530000000000e-07 3.781487329874e-02
+ 1.540000000000e-07 3.805883483303e-02
+ 1.550000000000e-07 3.830279636731e-02
+ 1.560000000000e-07 3.854675790160e-02
+ 1.570000000000e-07 3.879071943588e-02
+ 1.580000000000e-07 3.903468097016e-02
+ 1.590000000000e-07 3.927864250445e-02
+ 1.600000000000e-07 3.952260403873e-02
+ 1.610000000000e-07 3.976656557302e-02
+ 1.620000000000e-07 4.001052710730e-02
+ 1.630000000000e-07 4.025448864159e-02
+ 1.640000000000e-07 4.049845017587e-02
+ 1.650000000000e-07 4.074241171015e-02
+ 1.660000000000e-07 4.098637324444e-02
+ 1.670000000000e-07 4.123033477872e-02
+ 1.680000000000e-07 4.147429631301e-02
+ 1.690000000000e-07 4.171825784729e-02
+ 1.700000000000e-07 4.196221938157e-02
+ 1.710000000000e-07 4.220618091586e-02
+ 1.720000000000e-07 4.245014245014e-02
+ 1.730000000000e-07 4.269410398443e-02
+ 1.740000000000e-07 4.293806551871e-02
+ 1.750000000000e-07 4.318202705299e-02
+ 1.760000000000e-07 4.342598858728e-02
+ 1.770000000000e-07 4.366995012156e-02
+ 1.780000000000e-07 4.391391165585e-02
+ 1.790000000000e-07 4.415787319013e-02
+ 1.800000000000e-07 4.440183472442e-02
+ 1.810000000000e-07 4.464579625870e-02
+ 1.820000000000e-07 4.488975779298e-02
+ 1.830000000000e-07 4.513371932727e-02
+ 1.840000000000e-07 4.537768086155e-02
+ 1.850000000000e-07 4.562164239584e-02
+ 1.860000000000e-07 4.586560393012e-02
+ 1.870000000000e-07 4.610956546440e-02
+ 1.880000000000e-07 4.635352699869e-02
+ 1.890000000000e-07 4.659748853297e-02
+ 1.900000000000e-07 4.684145006726e-02
+ 1.910000000000e-07 4.708541160154e-02
+ 1.920000000000e-07 4.732937313582e-02
+ 1.930000000000e-07 4.757333467011e-02
+ 1.940000000000e-07 4.781729620439e-02
+ 1.950000000000e-07 4.806125773868e-02
+ 1.960000000000e-07 4.830521927296e-02
+ 1.970000000000e-07 4.854918080725e-02
+ 1.980000000000e-07 4.879314234153e-02
+ 1.990000000000e-07 4.903710387581e-02
+ 2.000000000000e-07 4.928106541010e-02
+ 2.010000000000e-07 4.952502694438e-02
+ 2.020000000000e-07 4.976898847867e-02
+ 2.030000000000e-07 5.001295001295e-02
+ 2.040000000000e-07 5.025691154723e-02
+ 2.050000000000e-07 5.050087308152e-02
+ 2.060000000000e-07 5.074483461580e-02
+ 2.070000000000e-07 5.098879615009e-02
+ 2.080000000000e-07 5.123275768437e-02
+ 2.090000000000e-07 5.147671921865e-02
+ 2.100000000000e-07 5.172068075294e-02
+ 2.110000000000e-07 5.196464228722e-02
+ 2.120000000000e-07 5.220860382151e-02
+ 2.130000000000e-07 5.245256535579e-02
+ 2.140000000000e-07 5.269652689008e-02
+ 2.150000000000e-07 5.294048842436e-02
+ 2.160000000000e-07 5.318444995864e-02
+ 2.170000000000e-07 5.342841149293e-02
+ 2.180000000000e-07 5.367237302721e-02
+ 2.190000000000e-07 5.391633456150e-02
+ 2.200000000000e-07 5.416029609578e-02
+ 2.210000000000e-07 5.440425763006e-02
+ 2.220000000000e-07 5.464821916435e-02
+ 2.230000000000e-07 5.489218069863e-02
+ 2.240000000000e-07 5.513614223292e-02
+ 2.250000000000e-07 5.538010376720e-02
+ 2.260000000000e-07 5.562406530148e-02
+ 2.270000000000e-07 5.586802683577e-02
+ 2.280000000000e-07 5.611198837005e-02
+ 2.290000000000e-07 5.635594990434e-02
+ 2.300000000000e-07 5.659991143862e-02
+ 2.310000000000e-07 5.684387297291e-02
+ 2.320000000000e-07 5.708783450719e-02
+ 2.330000000000e-07 5.733179604147e-02
+ 2.340000000000e-07 5.757575757576e-02
+ 2.350000000000e-07 5.781971911004e-02
+ 2.360000000000e-07 5.806368064433e-02
+ 2.370000000000e-07 5.830764217861e-02
+ 2.380000000000e-07 5.855160371289e-02
+ 2.390000000000e-07 5.879556524718e-02
+ 2.400000000000e-07 5.903952678146e-02
+ 2.410000000000e-07 5.928348831575e-02
+ 2.420000000000e-07 5.952744985003e-02
+ 2.430000000000e-07 5.977141138431e-02
+ 2.440000000000e-07 6.001537291860e-02
+ 2.450000000000e-07 6.025933445288e-02
+ 2.460000000000e-07 6.050329598717e-02
+ 2.470000000000e-07 6.074725752145e-02
+ 2.480000000000e-07 6.099121905574e-02
+ 2.490000000000e-07 6.123518059002e-02
+ 2.500000000000e-07 6.147914212430e-02
+ 2.510000000000e-07 6.172310365859e-02
+ 2.520000000000e-07 6.196706519287e-02
+ 2.530000000000e-07 6.221102672716e-02
+ 2.540000000000e-07 6.245498826144e-02
+ 2.550000000000e-07 6.269894979572e-02
+ 2.560000000000e-07 6.294291133001e-02
+ 2.570000000000e-07 6.318687286429e-02
+ 2.580000000000e-07 6.343083439858e-02
+ 2.590000000000e-07 6.367479593286e-02
+ 2.600000000000e-07 6.391875746714e-02
+ 2.610000000000e-07 6.416271900143e-02
+ 2.620000000000e-07 6.440668053571e-02
+ 2.630000000000e-07 6.465064207000e-02
+ 2.640000000000e-07 6.489460360428e-02
+ 2.650000000000e-07 6.513856513857e-02
+ 2.660000000000e-07 6.538252667285e-02
+ 2.670000000000e-07 6.562648820713e-02
+ 2.680000000000e-07 6.587044974142e-02
+ 2.690000000000e-07 6.611441127570e-02
+ 2.700000000000e-07 6.635837280999e-02
+ 2.710000000000e-07 6.660233434427e-02
+ 2.720000000000e-07 6.684629587855e-02
+ 2.730000000000e-07 6.709025741284e-02
+ 2.740000000000e-07 6.733421894712e-02
+ 2.750000000000e-07 6.757818048141e-02
+ 2.760000000000e-07 6.782214201569e-02
+ 2.770000000000e-07 6.806610354997e-02
+ 2.780000000000e-07 6.831006508426e-02
+ 2.790000000000e-07 6.855402661854e-02
+ 2.800000000000e-07 6.879798815283e-02
+ 2.810000000000e-07 6.904194968711e-02
+ 2.820000000000e-07 6.928591122140e-02
+ 2.830000000000e-07 6.952987275568e-02
+ 2.840000000000e-07 6.977383428996e-02
+ 2.850000000000e-07 7.001779582425e-02
+ 2.860000000000e-07 7.026175735853e-02
+ 2.870000000000e-07 7.050571889282e-02
+ 2.880000000000e-07 7.074968042710e-02
+ 2.890000000000e-07 7.099364196138e-02
+ 2.900000000000e-07 7.123760349567e-02
+ 2.910000000000e-07 7.148156502995e-02
+ 2.920000000000e-07 7.172552656424e-02
+ 2.930000000000e-07 7.196948809852e-02
+ 2.940000000000e-07 7.221344963280e-02
+ 2.950000000000e-07 7.245741116709e-02
+ 2.960000000000e-07 7.270137270137e-02
+ 2.970000000000e-07 7.294533423566e-02
+ 2.980000000000e-07 7.318929576994e-02
+ 2.990000000000e-07 7.343325730423e-02
+ 3.000000000000e-07 7.367721883851e-02
+ 3.010000000000e-07 7.392118037279e-02
+ 3.020000000000e-07 7.416514190708e-02
+ 3.030000000000e-07 7.440910344136e-02
+ 3.040000000000e-07 7.465306497565e-02
+ 3.050000000000e-07 7.489702650993e-02
+ 3.060000000000e-07 7.514098804421e-02
+ 3.070000000000e-07 7.538494957850e-02
+ 3.080000000000e-07 7.562891111278e-02
+ 3.090000000000e-07 7.587287264707e-02
+ 3.100000000000e-07 7.611683418135e-02
+ 3.110000000000e-07 7.636079571563e-02
+ 3.120000000000e-07 7.660475724992e-02
+ 3.130000000000e-07 7.684871878420e-02
+ 3.140000000000e-07 7.709268031849e-02
+ 3.150000000000e-07 7.733664185277e-02
+ 3.160000000000e-07 7.758060338705e-02
+ 3.170000000000e-07 7.782456492134e-02
+ 3.180000000000e-07 7.806852645562e-02
+ 3.190000000000e-07 7.831248798991e-02
+ 3.200000000000e-07 7.855644952419e-02
+ 3.210000000000e-07 7.880041105848e-02
+ 3.220000000000e-07 7.904437259276e-02
+ 3.230000000000e-07 7.928833412704e-02
+ 3.240000000000e-07 7.953229566133e-02
+ 3.250000000000e-07 7.977625719561e-02
+ 3.260000000000e-07 8.002021872990e-02
+ 3.270000000000e-07 8.026418026418e-02
+ 3.280000000000e-07 8.050814179846e-02
+ 3.290000000000e-07 8.075210333275e-02
+ 3.300000000000e-07 8.099606486703e-02
+ 3.310000000000e-07 8.124002640132e-02
+ 3.320000000000e-07 8.148398793560e-02
+ 3.330000000000e-07 8.172794946988e-02
+ 3.340000000000e-07 8.197191100417e-02
+ 3.350000000000e-07 8.221587253845e-02
+ 3.360000000000e-07 8.245983407274e-02
+ 3.370000000000e-07 8.270379560702e-02
+ 3.380000000000e-07 8.294775714131e-02
+ 3.390000000000e-07 8.319171867559e-02
+ 3.400000000000e-07 8.343568020987e-02
+ 3.410000000000e-07 8.367964174416e-02
+ 3.420000000000e-07 8.392360327844e-02
+ 3.430000000000e-07 8.416756481273e-02
+ 3.440000000000e-07 8.441152634701e-02
+ 3.450000000000e-07 8.465548788129e-02
+ 3.460000000000e-07 8.489944941558e-02
+ 3.470000000000e-07 8.514341094986e-02
+ 3.480000000000e-07 8.538737248415e-02
+ 3.490000000000e-07 8.563133401843e-02
+ 3.500000000000e-07 8.587529555271e-02
+ 3.510000000000e-07 8.611925708700e-02
+ 3.520000000000e-07 8.636321862128e-02
+ 3.530000000000e-07 8.660718015557e-02
+ 3.540000000000e-07 8.685114168985e-02
+ 3.550000000000e-07 8.709510322414e-02
+ 3.560000000000e-07 8.733906475842e-02
+ 3.570000000000e-07 8.758302629270e-02
+ 3.580000000000e-07 8.782698782699e-02
+ 3.590000000000e-07 8.807094936127e-02
+ 3.600000000000e-07 8.831491089556e-02
+ 3.610000000000e-07 8.855887242984e-02
+ 3.620000000000e-07 8.880283396412e-02
+ 3.630000000000e-07 8.904679549841e-02
+ 3.640000000000e-07 8.929075703269e-02
+ 3.650000000000e-07 8.953471856698e-02
+ 3.660000000000e-07 8.977868010126e-02
+ 3.670000000000e-07 9.002264163554e-02
+ 3.680000000000e-07 9.026660316983e-02
+ 3.690000000000e-07 9.051056470411e-02
+ 3.700000000000e-07 9.075452623840e-02
+ 3.710000000000e-07 9.099848777268e-02
+ 3.720000000000e-07 9.124244930697e-02
+ 3.730000000000e-07 9.148641084125e-02
+ 3.740000000000e-07 9.173037237553e-02
+ 3.750000000000e-07 9.197433390982e-02
+ 3.760000000000e-07 9.221829544410e-02
+ 3.770000000000e-07 9.246225697839e-02
+ 3.780000000000e-07 9.270621851267e-02
+ 3.790000000000e-07 9.295018004695e-02
+ 3.800000000000e-07 9.319414158124e-02
+ 3.810000000000e-07 9.343810311552e-02
+ 3.820000000000e-07 9.368206464981e-02
+ 3.830000000000e-07 9.392602618409e-02
+ 3.840000000000e-07 9.416998771837e-02
+ 3.850000000000e-07 9.441394925266e-02
+ 3.860000000000e-07 9.465791078694e-02
+ 3.870000000000e-07 9.490187232123e-02
+ 3.880000000000e-07 9.514583385551e-02
+ 3.890000000000e-07 9.538979538980e-02
+ 3.900000000000e-07 9.563375692408e-02
+ 3.910000000000e-07 9.587771845836e-02
+ 3.920000000000e-07 9.612167999265e-02
+ 3.930000000000e-07 9.636564152693e-02
+ 3.940000000000e-07 9.660960306122e-02
+ 3.950000000000e-07 9.685356459550e-02
+ 3.960000000000e-07 9.709752612978e-02
+ 3.970000000000e-07 9.734148766407e-02
+ 3.980000000000e-07 9.758544919835e-02
+ 3.990000000000e-07 9.782941073264e-02
+ 4.000000000000e-07 9.807337226692e-02
+ 4.010000000000e-07 9.831733380120e-02
+ 4.020000000000e-07 9.856129533549e-02
+ 4.030000000000e-07 9.880525686977e-02
+ 4.040000000000e-07 9.904921840406e-02
+ 4.050000000000e-07 9.929317993834e-02
+ 4.060000000000e-07 9.953714147263e-02
+ 4.070000000000e-07 9.978110300691e-02
+ 4.080000000000e-07 1.000250645412e-01
+ 4.090000000000e-07 1.002690260755e-01
+ 4.100000000000e-07 1.005129876098e-01
+ 4.110000000000e-07 1.007569491440e-01
+ 4.120000000000e-07 1.010009106783e-01
+ 4.130000000000e-07 1.012448722126e-01
+ 4.140000000000e-07 1.014888337469e-01
+ 4.150000000000e-07 1.017327952812e-01
+ 4.160000000000e-07 1.019767568155e-01
+ 4.170000000000e-07 1.022207183498e-01
+ 4.180000000000e-07 1.024646798840e-01
+ 4.190000000000e-07 1.027086414183e-01
+ 4.200000000000e-07 1.029526029526e-01
+ 4.210000000000e-07 1.031965644869e-01
+ 4.220000000000e-07 1.034405260212e-01
+ 4.230000000000e-07 1.036844875555e-01
+ 4.240000000000e-07 1.039284490897e-01
+ 4.250000000000e-07 1.041724106240e-01
+ 4.260000000000e-07 1.044163721583e-01
+ 4.270000000000e-07 1.046603336926e-01
+ 4.280000000000e-07 1.049042952269e-01
+ 4.290000000000e-07 1.051482567612e-01
+ 4.300000000000e-07 1.053922182954e-01
+ 4.310000000000e-07 1.056361798297e-01
+ 4.320000000000e-07 1.058801413640e-01
+ 4.330000000000e-07 1.061241028983e-01
+ 4.340000000000e-07 1.063680644326e-01
+ 4.350000000000e-07 1.066120259669e-01
+ 4.360000000000e-07 1.068559875011e-01
+ 4.370000000000e-07 1.070999490354e-01
+ 4.380000000000e-07 1.073439105697e-01
+ 4.390000000000e-07 1.075878721040e-01
+ 4.400000000000e-07 1.078318336383e-01
+ 4.410000000000e-07 1.080757951726e-01
+ 4.420000000000e-07 1.083197567069e-01
+ 4.430000000000e-07 1.085637182411e-01
+ 4.440000000000e-07 1.088076797754e-01
+ 4.450000000000e-07 1.090516413097e-01
+ 4.460000000000e-07 1.092956028440e-01
+ 4.470000000000e-07 1.095395643783e-01
+ 4.480000000000e-07 1.097835259126e-01
+ 4.490000000000e-07 1.100274874468e-01
+ 4.500000000000e-07 1.102714489811e-01
+ 4.510000000000e-07 1.105154105154e-01
+ 4.520000000000e-07 1.107593720497e-01
+ 4.530000000000e-07 1.110033335840e-01
+ 4.540000000000e-07 1.112472951183e-01
+ 4.550000000000e-07 1.114912566525e-01
+ 4.560000000000e-07 1.117352181868e-01
+ 4.570000000000e-07 1.119791797211e-01
+ 4.580000000000e-07 1.122231412554e-01
+ 4.590000000000e-07 1.124671027897e-01
+ 4.600000000000e-07 1.127110643240e-01
+ 4.610000000000e-07 1.129550258583e-01
+ 4.620000000000e-07 1.131989873925e-01
+ 4.630000000000e-07 1.134429489268e-01
+ 4.640000000000e-07 1.136869104611e-01
+ 4.650000000000e-07 1.139308719954e-01
+ 4.660000000000e-07 1.141748335297e-01
+ 4.670000000000e-07 1.144187950640e-01
+ 4.680000000000e-07 1.146627565982e-01
+ 4.690000000000e-07 1.149067181325e-01
+ 4.700000000000e-07 1.151506796668e-01
+ 4.710000000000e-07 1.153946412011e-01
+ 4.720000000000e-07 1.156386027354e-01
+ 4.730000000000e-07 1.158825642697e-01
+ 4.740000000000e-07 1.161265258039e-01
+ 4.750000000000e-07 1.163704873382e-01
+ 4.760000000000e-07 1.166144488725e-01
+ 4.770000000000e-07 1.168584104068e-01
+ 4.780000000000e-07 1.171023719411e-01
+ 4.790000000000e-07 1.173463334754e-01
+ 4.800000000000e-07 1.175902950096e-01
+ 4.810000000000e-07 1.178342565439e-01
+ 4.820000000000e-07 1.180782180782e-01
+ 4.830000000000e-07 1.183221796125e-01
+ 4.840000000000e-07 1.185661411468e-01
+ 4.850000000000e-07 1.188101026811e-01
+ 4.860000000000e-07 1.190540642154e-01
+ 4.870000000000e-07 1.192980257496e-01
+ 4.880000000000e-07 1.195419872839e-01
+ 4.890000000000e-07 1.197859488182e-01
+ 4.900000000000e-07 1.200299103525e-01
+ 4.910000000000e-07 1.202738718868e-01
+ 4.920000000000e-07 1.205178334211e-01
+ 4.930000000000e-07 1.207617949553e-01
+ 4.940000000000e-07 1.210057564896e-01
+ 4.950000000000e-07 1.212497180239e-01
+ 4.960000000000e-07 1.214936795582e-01
+ 4.970000000000e-07 1.217376410925e-01
+ 4.980000000000e-07 1.219816026268e-01
+ 4.990000000000e-07 1.222255641610e-01
+ 5.000000000000e-07 1.224695256953e-01
+ 5.010000000000e-07 1.227134872296e-01
+ 5.020000000000e-07 1.229574487639e-01
+ 5.030000000000e-07 1.232014102982e-01
+ 5.040000000000e-07 1.234453718325e-01
+ 5.050000000000e-07 1.236893333668e-01
+ 5.060000000000e-07 1.239332949010e-01
+ 5.070000000000e-07 1.241772564353e-01
+ 5.080000000000e-07 1.244212179696e-01
+ 5.090000000000e-07 1.246651795039e-01
+ 5.100000000000e-07 1.249091410382e-01
+ 5.110000000000e-07 1.251531025725e-01
+ 5.120000000000e-07 1.253970641067e-01
+ 5.130000000000e-07 1.256410256410e-01
+ 5.140000000000e-07 1.258849871753e-01
+ 5.150000000000e-07 1.261289487096e-01
+ 5.160000000000e-07 1.263729102439e-01
+ 5.170000000000e-07 1.266168717782e-01
+ 5.180000000000e-07 1.268608333124e-01
+ 5.190000000000e-07 1.271047948467e-01
+ 5.200000000000e-07 1.273487563810e-01
+ 5.210000000000e-07 1.275927179153e-01
+ 5.220000000000e-07 1.278366794496e-01
+ 5.230000000000e-07 1.280806409839e-01
+ 5.240000000000e-07 1.283246025182e-01
+ 5.250000000000e-07 1.285685640524e-01
+ 5.260000000000e-07 1.288125255867e-01
+ 5.270000000000e-07 1.290564871210e-01
+ 5.280000000000e-07 1.293004486553e-01
+ 5.290000000000e-07 1.295444101896e-01
+ 5.300000000000e-07 1.297883717239e-01
+ 5.310000000000e-07 1.300323332581e-01
+ 5.320000000000e-07 1.302762947924e-01
+ 5.330000000000e-07 1.305202563267e-01
+ 5.340000000000e-07 1.307642178610e-01
+ 5.350000000000e-07 1.310081793953e-01
+ 5.360000000000e-07 1.312521409296e-01
+ 5.370000000000e-07 1.314961024638e-01
+ 5.380000000000e-07 1.317400639981e-01
+ 5.390000000000e-07 1.319840255324e-01
+ 5.400000000000e-07 1.322279870667e-01
+ 5.410000000000e-07 1.324719486010e-01
+ 5.420000000000e-07 1.327159101353e-01
+ 5.430000000000e-07 1.329598716695e-01
+ 5.440000000000e-07 1.332038332038e-01
+ 5.450000000000e-07 1.334477947381e-01
+ 5.460000000000e-07 1.336917562724e-01
+ 5.470000000000e-07 1.339357178067e-01
+ 5.480000000000e-07 1.341796793410e-01
+ 5.490000000000e-07 1.344236408753e-01
+ 5.500000000000e-07 1.346676024095e-01
+ 5.510000000000e-07 1.349115639438e-01
+ 5.520000000000e-07 1.351555254781e-01
+ 5.530000000000e-07 1.353994870124e-01
+ 5.540000000000e-07 1.356434485467e-01
+ 5.550000000000e-07 1.358874100810e-01
+ 5.560000000000e-07 1.361313716152e-01
+ 5.570000000000e-07 1.363753331495e-01
+ 5.580000000000e-07 1.366192946838e-01
+ 5.590000000000e-07 1.368632562181e-01
+ 5.600000000000e-07 1.371072177524e-01
+ 5.610000000000e-07 1.373511792867e-01
+ 5.620000000000e-07 1.375951408209e-01
+ 5.630000000000e-07 1.378391023552e-01
+ 5.640000000000e-07 1.380830638895e-01
+ 5.650000000000e-07 1.383270254238e-01
+ 5.660000000000e-07 1.385709869581e-01
+ 5.670000000000e-07 1.388149484924e-01
+ 5.680000000000e-07 1.390589100267e-01
+ 5.690000000000e-07 1.393028715609e-01
+ 5.700000000000e-07 1.395468330952e-01
+ 5.710000000000e-07 1.397907946295e-01
+ 5.720000000000e-07 1.400347561638e-01
+ 5.730000000000e-07 1.402787176981e-01
+ 5.740000000000e-07 1.405226792324e-01
+ 5.750000000000e-07 1.407666407666e-01
+ 5.760000000000e-07 1.410106023009e-01
+ 5.770000000000e-07 1.412545638352e-01
+ 5.780000000000e-07 1.414985253695e-01
+ 5.790000000000e-07 1.417424869038e-01
+ 5.800000000000e-07 1.419864484381e-01
+ 5.810000000000e-07 1.422304099723e-01
+ 5.820000000000e-07 1.424743715066e-01
+ 5.830000000000e-07 1.427183330409e-01
+ 5.840000000000e-07 1.429622945752e-01
+ 5.850000000000e-07 1.432062561095e-01
+ 5.860000000000e-07 1.434502176438e-01
+ 5.870000000000e-07 1.436941791781e-01
+ 5.880000000000e-07 1.439381407123e-01
+ 5.890000000000e-07 1.441821022466e-01
+ 5.900000000000e-07 1.444260637809e-01
+ 5.910000000000e-07 1.446700253152e-01
+ 5.920000000000e-07 1.449139868495e-01
+ 5.930000000000e-07 1.451579483838e-01
+ 5.940000000000e-07 1.454019099180e-01
+ 5.950000000000e-07 1.456458714523e-01
+ 5.960000000000e-07 1.458898329866e-01
+ 5.970000000000e-07 1.461337945209e-01
+ 5.980000000000e-07 1.463777560552e-01
+ 5.990000000000e-07 1.466217175895e-01
+ 6.000000000000e-07 1.468656791237e-01
+ 6.010000000000e-07 1.471096406580e-01
+ 6.020000000000e-07 1.473536021923e-01
+ 6.030000000000e-07 1.475975637266e-01
+ 6.040000000000e-07 1.478415252609e-01
+ 6.050000000000e-07 1.480854867952e-01
+ 6.060000000000e-07 1.483294483294e-01
+ 6.070000000000e-07 1.485734098637e-01
+ 6.080000000000e-07 1.488173713980e-01
+ 6.090000000000e-07 1.490613329323e-01
+ 6.100000000000e-07 1.493052944666e-01
+ 6.110000000000e-07 1.495492560009e-01
+ 6.120000000000e-07 1.497932175352e-01
+ 6.130000000000e-07 1.500371790694e-01
+ 6.140000000000e-07 1.502811406037e-01
+ 6.150000000000e-07 1.505251021380e-01
+ 6.160000000000e-07 1.507690636723e-01
+ 6.170000000000e-07 1.510130252066e-01
+ 6.180000000000e-07 1.512569867409e-01
+ 6.190000000000e-07 1.515009482751e-01
+ 6.200000000000e-07 1.517449098094e-01
+ 6.210000000000e-07 1.519888713437e-01
+ 6.220000000000e-07 1.522328328780e-01
+ 6.230000000000e-07 1.524767944123e-01
+ 6.240000000000e-07 1.527207559466e-01
+ 6.250000000000e-07 1.529647174808e-01
+ 6.260000000000e-07 1.532086790151e-01
+ 6.270000000000e-07 1.534526405494e-01
+ 6.280000000000e-07 1.536966020837e-01
+ 6.290000000000e-07 1.539405636180e-01
+ 6.300000000000e-07 1.541845251523e-01
+ 6.310000000000e-07 1.544284866866e-01
+ 6.320000000000e-07 1.546724482208e-01
+ 6.330000000000e-07 1.549164097551e-01
+ 6.340000000000e-07 1.551603712894e-01
+ 6.350000000000e-07 1.554043328237e-01
+ 6.360000000000e-07 1.556482943580e-01
+ 6.370000000000e-07 1.558922558923e-01
+ 6.380000000000e-07 1.561362174265e-01
+ 6.390000000000e-07 1.563801789608e-01
+ 6.400000000000e-07 1.566241404951e-01
+ 6.410000000000e-07 1.568681020294e-01
+ 6.420000000000e-07 1.571120635637e-01
+ 6.430000000000e-07 1.573560250980e-01
+ 6.440000000000e-07 1.575999866322e-01
+ 6.450000000000e-07 1.578439481665e-01
+ 6.460000000000e-07 1.580879097008e-01
+ 6.470000000000e-07 1.583318712351e-01
+ 6.480000000000e-07 1.585758327694e-01
+ 6.490000000000e-07 1.588197943037e-01
+ 6.500000000000e-07 1.590637558379e-01
+ 6.510000000000e-07 1.593077173722e-01
+ 6.520000000000e-07 1.595516789065e-01
+ 6.530000000000e-07 1.597956404408e-01
+ 6.540000000000e-07 1.600396019751e-01
+ 6.550000000000e-07 1.602835635094e-01
+ 6.560000000000e-07 1.605275250437e-01
+ 6.570000000000e-07 1.607714865779e-01
+ 6.580000000000e-07 1.610154481122e-01
+ 6.590000000000e-07 1.612594096465e-01
+ 6.600000000000e-07 1.615033711808e-01
+ 6.610000000000e-07 1.617473327151e-01
+ 6.620000000000e-07 1.619912942494e-01
+ 6.630000000000e-07 1.622352557836e-01
+ 6.640000000000e-07 1.624792173179e-01
+ 6.650000000000e-07 1.627231788522e-01
+ 6.660000000000e-07 1.629671403865e-01
+ 6.670000000000e-07 1.632111019208e-01
+ 6.680000000000e-07 1.634550634551e-01
+ 6.690000000000e-07 1.636990249893e-01
+ 6.700000000000e-07 1.639429865236e-01
+ 6.710000000000e-07 1.641869480579e-01
+ 6.720000000000e-07 1.644309095922e-01
+ 6.730000000000e-07 1.646748711265e-01
+ 6.740000000000e-07 1.649188326608e-01
+ 6.750000000000e-07 1.651627941951e-01
+ 6.760000000000e-07 1.654067557293e-01
+ 6.770000000000e-07 1.656507172636e-01
+ 6.780000000000e-07 1.658946787979e-01
+ 6.790000000000e-07 1.661386403322e-01
+ 6.800000000000e-07 1.663826018665e-01
+ 6.810000000000e-07 1.666265634008e-01
+ 6.820000000000e-07 1.668705249350e-01
+ 6.830000000000e-07 1.671144864693e-01
+ 6.840000000000e-07 1.673584480036e-01
+ 6.850000000000e-07 1.676024095379e-01
+ 6.860000000000e-07 1.678463710722e-01
+ 6.870000000000e-07 1.680903326065e-01
+ 6.880000000000e-07 1.683342941407e-01
+ 6.890000000000e-07 1.685782556750e-01
+ 6.900000000000e-07 1.688222172093e-01
+ 6.910000000000e-07 1.690661787436e-01
+ 6.920000000000e-07 1.693101402779e-01
+ 6.930000000000e-07 1.695541018122e-01
+ 6.940000000000e-07 1.697980633465e-01
+ 6.950000000000e-07 1.700420248807e-01
+ 6.960000000000e-07 1.702859864150e-01
+ 6.970000000000e-07 1.705299479493e-01
+ 6.980000000000e-07 1.707739094836e-01
+ 6.990000000000e-07 1.710178710179e-01
+ 7.000000000000e-07 1.712618325522e-01
+ 7.010000000000e-07 1.715057940864e-01
+ 7.020000000000e-07 1.717497556207e-01
+ 7.030000000000e-07 1.719937171550e-01
+ 7.040000000000e-07 1.722376786893e-01
+ 7.050000000000e-07 1.724816402236e-01
+ 7.060000000000e-07 1.727256017579e-01
+ 7.070000000000e-07 1.729695632921e-01
+ 7.080000000000e-07 1.732135248264e-01
+ 7.090000000000e-07 1.734574863607e-01
+ 7.100000000000e-07 1.737014478950e-01
+ 7.110000000000e-07 1.739454094293e-01
+ 7.120000000000e-07 1.741893709636e-01
+ 7.130000000000e-07 1.744333324978e-01
+ 7.140000000000e-07 1.746772940321e-01
+ 7.150000000000e-07 1.749212555664e-01
+ 7.160000000000e-07 1.751652171007e-01
+ 7.170000000000e-07 1.754091786350e-01
+ 7.180000000000e-07 1.756531401693e-01
+ 7.190000000000e-07 1.758971017036e-01
+ 7.200000000000e-07 1.761410632378e-01
+ 7.210000000000e-07 1.763850247721e-01
+ 7.220000000000e-07 1.766289863064e-01
+ 7.230000000000e-07 1.768729478407e-01
+ 7.240000000000e-07 1.771169093750e-01
+ 7.250000000000e-07 1.773608709093e-01
+ 7.260000000000e-07 1.776048324435e-01
+ 7.270000000000e-07 1.778487939778e-01
+ 7.280000000000e-07 1.780927555121e-01
+ 7.290000000000e-07 1.783367170464e-01
+ 7.300000000000e-07 1.785806785807e-01
+ 7.310000000000e-07 1.788246401150e-01
+ 7.320000000000e-07 1.790686016492e-01
+ 7.330000000000e-07 1.793125631835e-01
+ 7.340000000000e-07 1.795565247178e-01
+ 7.350000000000e-07 1.798004862521e-01
+ 7.360000000000e-07 1.800444477864e-01
+ 7.370000000000e-07 1.802884093207e-01
+ 7.380000000000e-07 1.805323708550e-01
+ 7.390000000000e-07 1.807763323892e-01
+ 7.400000000000e-07 1.810202939235e-01
+ 7.410000000000e-07 1.812642554578e-01
+ 7.420000000000e-07 1.815082169921e-01
+ 7.430000000000e-07 1.817521785264e-01
+ 7.440000000000e-07 1.819961400607e-01
+ 7.450000000000e-07 1.822401015949e-01
+ 7.460000000000e-07 1.824840631292e-01
+ 7.470000000000e-07 1.827280246635e-01
+ 7.480000000000e-07 1.829719861978e-01
+ 7.490000000000e-07 1.832159477321e-01
+ 7.500000000000e-07 1.834599092664e-01
+ 7.510000000000e-07 1.837038708006e-01
+ 7.520000000000e-07 1.839478323349e-01
+ 7.530000000000e-07 1.841917938692e-01
+ 7.540000000000e-07 1.844357554035e-01
+ 7.550000000000e-07 1.846797169378e-01
+ 7.560000000000e-07 1.849236784721e-01
+ 7.570000000000e-07 1.851676400063e-01
+ 7.580000000000e-07 1.854116015406e-01
+ 7.590000000000e-07 1.856555630749e-01
+ 7.600000000000e-07 1.858995246092e-01
+ 7.610000000000e-07 1.861434861435e-01
+ 7.620000000000e-07 1.863874476778e-01
+ 7.630000000000e-07 1.866314092121e-01
+ 7.640000000000e-07 1.868753707463e-01
+ 7.650000000000e-07 1.871193322806e-01
+ 7.660000000000e-07 1.873632938149e-01
+ 7.670000000000e-07 1.876072553492e-01
+ 7.680000000000e-07 1.878512168835e-01
+ 7.690000000000e-07 1.880951784178e-01
+ 7.700000000000e-07 1.883391399520e-01
+ 7.710000000000e-07 1.885831014863e-01
+ 7.720000000000e-07 1.888270630206e-01
+ 7.730000000000e-07 1.890710245549e-01
+ 7.740000000000e-07 1.893149860892e-01
+ 7.750000000000e-07 1.895589476235e-01
+ 7.760000000000e-07 1.898029091577e-01
+ 7.770000000000e-07 1.900468706920e-01
+ 7.780000000000e-07 1.902908322263e-01
+ 7.790000000000e-07 1.905347937606e-01
+ 7.800000000000e-07 1.907787552949e-01
+ 7.810000000000e-07 1.910227168292e-01
+ 7.820000000000e-07 1.912666783635e-01
+ 7.830000000000e-07 1.915106398977e-01
+ 7.840000000000e-07 1.917546014320e-01
+ 7.850000000000e-07 1.919985629663e-01
+ 7.860000000000e-07 1.922425245006e-01
+ 7.870000000000e-07 1.924864860349e-01
+ 7.880000000000e-07 1.927304475692e-01
+ 7.890000000000e-07 1.929744091034e-01
+ 7.900000000000e-07 1.932183706377e-01
+ 7.910000000000e-07 1.934623321720e-01
+ 7.920000000000e-07 1.937062937063e-01
+ 7.930000000000e-07 1.939502552406e-01
+ 7.940000000000e-07 1.941942167749e-01
+ 7.950000000000e-07 1.944381783091e-01
+ 7.960000000000e-07 1.946821398434e-01
+ 7.970000000000e-07 1.949261013777e-01
+ 7.980000000000e-07 1.951700629120e-01
+ 7.990000000000e-07 1.954140244463e-01
+ 8.000000000000e-07 1.956579859806e-01
+ 8.010000000000e-07 1.959019475149e-01
+ 8.020000000000e-07 1.961459090491e-01
+ 8.030000000000e-07 1.963898705834e-01
+ 8.040000000000e-07 1.966338321177e-01
+ 8.050000000000e-07 1.968777936520e-01
+ 8.060000000000e-07 1.971217551863e-01
+ 8.070000000000e-07 1.973657167206e-01
+ 8.080000000000e-07 1.976096782548e-01
+ 8.090000000000e-07 1.978536397891e-01
+ 8.100000000000e-07 1.980976013234e-01
+ 8.110000000000e-07 1.983415628577e-01
+ 8.120000000000e-07 1.985855243920e-01
+ 8.130000000000e-07 1.988294859263e-01
+ 8.140000000000e-07 1.990734474605e-01
+ 8.150000000000e-07 1.993174089948e-01
+ 8.160000000000e-07 1.995613705291e-01
+ 8.170000000000e-07 1.998053320634e-01
+ 8.180000000000e-07 2.000492935977e-01
+ 8.190000000000e-07 2.002932551320e-01
+ 8.200000000000e-07 2.005372166662e-01
+ 8.210000000000e-07 2.007811782005e-01
+ 8.220000000000e-07 2.010251397348e-01
+ 8.230000000000e-07 2.012691012691e-01
+ 8.240000000000e-07 2.015130628034e-01
+ 8.250000000000e-07 2.017570243377e-01
+ 8.260000000000e-07 2.020009858720e-01
+ 8.270000000000e-07 2.022449474062e-01
+ 8.280000000000e-07 2.024889089405e-01
+ 8.290000000000e-07 2.027328704748e-01
+ 8.300000000000e-07 2.029768320091e-01
+ 8.310000000000e-07 2.032207935434e-01
+ 8.320000000000e-07 2.034647550777e-01
+ 8.330000000000e-07 2.037087166119e-01
+ 8.340000000000e-07 2.039526781462e-01
+ 8.350000000000e-07 2.041966396805e-01
+ 8.360000000000e-07 2.044406012148e-01
+ 8.370000000000e-07 2.046845627491e-01
+ 8.380000000000e-07 2.049285242834e-01
+ 8.390000000000e-07 2.051724858176e-01
+ 8.400000000000e-07 2.054164473519e-01
+ 8.410000000000e-07 2.056604088862e-01
+ 8.420000000000e-07 2.059043704205e-01
+ 8.430000000000e-07 2.061483319548e-01
+ 8.440000000000e-07 2.063922934891e-01
+ 8.450000000000e-07 2.066362550234e-01
+ 8.460000000000e-07 2.068802165576e-01
+ 8.470000000000e-07 2.071241780919e-01
+ 8.480000000000e-07 2.073681396262e-01
+ 8.490000000000e-07 2.076121011605e-01
+ 8.500000000000e-07 2.078560626948e-01
+ 8.510000000000e-07 2.081000242291e-01
+ 8.520000000000e-07 2.083439857633e-01
+ 8.530000000000e-07 2.085879472976e-01
+ 8.540000000000e-07 2.088319088319e-01
+ 8.550000000000e-07 2.090758703662e-01
+ 8.560000000000e-07 2.093198319005e-01
+ 8.570000000000e-07 2.095637934348e-01
+ 8.580000000000e-07 2.098077549690e-01
+ 8.590000000000e-07 2.100517165033e-01
+ 8.600000000000e-07 2.102956780376e-01
+ 8.610000000000e-07 2.105396395719e-01
+ 8.620000000000e-07 2.107836011062e-01
+ 8.630000000000e-07 2.110275626405e-01
+ 8.640000000000e-07 2.112715241747e-01
+ 8.650000000000e-07 2.115154857090e-01
+ 8.660000000000e-07 2.117594472433e-01
+ 8.670000000000e-07 2.120034087776e-01
+ 8.680000000000e-07 2.122473703119e-01
+ 8.690000000000e-07 2.124913318462e-01
+ 8.700000000000e-07 2.127352933805e-01
+ 8.710000000000e-07 2.129792549147e-01
+ 8.720000000000e-07 2.132232164490e-01
+ 8.730000000000e-07 2.134671779833e-01
+ 8.740000000000e-07 2.137111395176e-01
+ 8.750000000000e-07 2.139551010519e-01
+ 8.760000000000e-07 2.141990625862e-01
+ 8.770000000000e-07 2.144430241204e-01
+ 8.780000000000e-07 2.146869856547e-01
+ 8.790000000000e-07 2.149309471890e-01
+ 8.800000000000e-07 2.151749087233e-01
+ 8.810000000000e-07 2.154188702576e-01
+ 8.820000000000e-07 2.156628317919e-01
+ 8.830000000000e-07 2.159067933261e-01
+ 8.840000000000e-07 2.161507548604e-01
+ 8.850000000000e-07 2.163947163947e-01
+ 8.860000000000e-07 2.166386779290e-01
+ 8.870000000000e-07 2.168826394633e-01
+ 8.880000000000e-07 2.171266009976e-01
+ 8.890000000000e-07 2.173705625319e-01
+ 8.900000000000e-07 2.176145240661e-01
+ 8.910000000000e-07 2.178584856004e-01
+ 8.920000000000e-07 2.181024471347e-01
+ 8.930000000000e-07 2.183464086690e-01
+ 8.940000000000e-07 2.185903702033e-01
+ 8.950000000000e-07 2.188343317376e-01
+ 8.960000000000e-07 2.190782932718e-01
+ 8.970000000000e-07 2.193222548061e-01
+ 8.980000000000e-07 2.195662163404e-01
+ 8.990000000000e-07 2.198101778747e-01
+ 9.000000000000e-07 2.200541394090e-01
+ 9.010000000000e-07 2.202981009433e-01
+ 9.020000000000e-07 2.205420624775e-01
+ 9.030000000000e-07 2.207860240118e-01
+ 9.040000000000e-07 2.210299855461e-01
+ 9.050000000000e-07 2.212739470804e-01
+ 9.060000000000e-07 2.215179086147e-01
+ 9.070000000000e-07 2.217618701490e-01
+ 9.080000000000e-07 2.220058316833e-01
+ 9.090000000000e-07 2.222497932175e-01
+ 9.100000000000e-07 2.224937547518e-01
+ 9.110000000000e-07 2.227377162861e-01
+ 9.120000000000e-07 2.229816778204e-01
+ 9.130000000000e-07 2.232256393547e-01
+ 9.140000000000e-07 2.234696008890e-01
+ 9.150000000000e-07 2.237135624232e-01
+ 9.160000000000e-07 2.239575239575e-01
+ 9.170000000000e-07 2.242014854918e-01
+ 9.180000000000e-07 2.244454470261e-01
+ 9.190000000000e-07 2.246894085604e-01
+ 9.200000000000e-07 2.249333700947e-01
+ 9.210000000000e-07 2.251773316289e-01
+ 9.220000000000e-07 2.254212931632e-01
+ 9.230000000000e-07 2.256652546975e-01
+ 9.240000000000e-07 2.259092162318e-01
+ 9.250000000000e-07 2.261531777661e-01
+ 9.260000000000e-07 2.263971393004e-01
+ 9.270000000000e-07 2.266411008346e-01
+ 9.280000000000e-07 2.268850623689e-01
+ 9.290000000000e-07 2.271290239032e-01
+ 9.300000000000e-07 2.273729854375e-01
+ 9.310000000000e-07 2.276169469718e-01
+ 9.320000000000e-07 2.278609085061e-01
+ 9.330000000000e-07 2.281048700404e-01
+ 9.340000000000e-07 2.283488315746e-01
+ 9.350000000000e-07 2.285927931089e-01
+ 9.360000000000e-07 2.288367546432e-01
+ 9.370000000000e-07 2.290807161775e-01
+ 9.380000000000e-07 2.293246777118e-01
+ 9.390000000000e-07 2.295686392461e-01
+ 9.400000000000e-07 2.298126007803e-01
+ 9.410000000000e-07 2.300565623146e-01
+ 9.420000000000e-07 2.303005238489e-01
+ 9.430000000000e-07 2.305444853832e-01
+ 9.440000000000e-07 2.307884469175e-01
+ 9.450000000000e-07 2.310324084518e-01
+ 9.460000000000e-07 2.312763699860e-01
+ 9.470000000000e-07 2.315203315203e-01
+ 9.480000000000e-07 2.317642930546e-01
+ 9.490000000000e-07 2.320082545889e-01
+ 9.500000000000e-07 2.322522161232e-01
+ 9.510000000000e-07 2.324961776575e-01
+ 9.520000000000e-07 2.327401391918e-01
+ 9.530000000000e-07 2.329841007260e-01
+ 9.540000000000e-07 2.332280622603e-01
+ 9.550000000000e-07 2.334720237946e-01
+ 9.560000000000e-07 2.337159853289e-01
+ 9.570000000000e-07 2.339599468632e-01
+ 9.580000000000e-07 2.342039083975e-01
+ 9.590000000000e-07 2.344478699317e-01
+ 9.600000000000e-07 2.346918314660e-01
+ 9.610000000000e-07 2.349357930003e-01
+ 9.620000000000e-07 2.351797545346e-01
+ 9.630000000000e-07 2.354237160689e-01
+ 9.640000000000e-07 2.356676776032e-01
+ 9.650000000000e-07 2.359116391374e-01
+ 9.660000000000e-07 2.361556006717e-01
+ 9.670000000000e-07 2.363995622060e-01
+ 9.680000000000e-07 2.366435237403e-01
+ 9.690000000000e-07 2.368874852746e-01
+ 9.700000000000e-07 2.371314468089e-01
+ 9.710000000000e-07 2.373754083432e-01
+ 9.720000000000e-07 2.376193698774e-01
+ 9.730000000000e-07 2.378633314117e-01
+ 9.740000000000e-07 2.381072929460e-01
+ 9.750000000000e-07 2.383512544803e-01
+ 9.760000000000e-07 2.385952160146e-01
+ 9.770000000000e-07 2.388391775489e-01
+ 9.780000000000e-07 2.390831390831e-01
+ 9.790000000000e-07 2.393271006174e-01
+ 9.800000000000e-07 2.395710621517e-01
+ 9.810000000000e-07 2.398150236860e-01
+ 9.820000000000e-07 2.400589852203e-01
+ 9.830000000000e-07 2.403029467546e-01
+ 9.840000000000e-07 2.405469082888e-01
+ 9.850000000000e-07 2.407908698231e-01
+ 9.860000000000e-07 2.410348313574e-01
+ 9.870000000000e-07 2.412787928917e-01
+ 9.880000000000e-07 2.415227544260e-01
+ 9.890000000000e-07 2.417667159603e-01
+ 9.900000000000e-07 2.420106774945e-01
+ 9.910000000000e-07 2.422546390288e-01
+ 9.920000000000e-07 2.424986005631e-01
+ 9.930000000000e-07 2.427425620974e-01
+ 9.940000000000e-07 2.429865236317e-01
+ 9.950000000000e-07 2.432304851660e-01
+ 9.960000000000e-07 2.434744467003e-01
+ 9.970000000000e-07 2.437184082345e-01
+ 9.980000000000e-07 2.439623697688e-01
+ 9.990000000000e-07 2.442063313031e-01
+ 1.000000000000e-06 2.444502928374e-01
+ 1.001000000000e-06 2.446942543717e-01
+ 1.002000000000e-06 2.449382159060e-01
+ 1.003000000000e-06 2.451821774402e-01
+ 1.004000000000e-06 2.454261389745e-01
+ 1.005000000000e-06 2.456701005088e-01
+ 1.006000000000e-06 2.459140620431e-01
+ 1.007000000000e-06 2.461580235774e-01
+ 1.008000000000e-06 2.464019851117e-01
+ 1.009000000000e-06 2.466459466459e-01
+ 1.010000000000e-06 2.468899081802e-01
+ 1.011000000000e-06 2.471338697145e-01
+ 1.012000000000e-06 2.473778312488e-01
+ 1.013000000000e-06 2.476217927831e-01
+ 1.014000000000e-06 2.478657543174e-01
+ 1.015000000000e-06 2.481097158517e-01
+ 1.016000000000e-06 2.483536773859e-01
+ 1.017000000000e-06 2.485976389202e-01
+ 1.018000000000e-06 2.488416004545e-01
+ 1.019000000000e-06 2.490855619888e-01
+ 1.020000000000e-06 2.493295235231e-01
+ 1.021000000000e-06 2.495734850574e-01
+ 1.022000000000e-06 2.498174465916e-01
+ 1.023000000000e-06 2.500614081259e-01
+ 1.024000000000e-06 2.503053696602e-01
+ 1.025000000000e-06 2.505493311945e-01
+ 1.026000000000e-06 2.507932927288e-01
+ 1.027000000000e-06 2.510372542631e-01
+ 1.028000000000e-06 2.512812157973e-01
+ 1.029000000000e-06 2.515251773316e-01
+ 1.030000000000e-06 2.517691388659e-01
+ 1.031000000000e-06 2.520131004002e-01
+ 1.032000000000e-06 2.522570619345e-01
+ 1.033000000000e-06 2.525010234688e-01
+ 1.034000000000e-06 2.527449850030e-01
+ 1.035000000000e-06 2.529889465373e-01
+ 1.036000000000e-06 2.532329080716e-01
+ 1.037000000000e-06 2.534768696059e-01
+ 1.038000000000e-06 2.537208311402e-01
+ 1.039000000000e-06 2.539647926745e-01
+ 1.040000000000e-06 2.542087542088e-01
+ 1.041000000000e-06 2.544527157430e-01
+ 1.042000000000e-06 2.546966772773e-01
+ 1.043000000000e-06 2.549406388116e-01
+ 1.044000000000e-06 2.551846003459e-01
+ 1.045000000000e-06 2.554285618802e-01
+ 1.046000000000e-06 2.556725234145e-01
+ 1.047000000000e-06 2.559164849487e-01
+ 1.048000000000e-06 2.561604464830e-01
+ 1.049000000000e-06 2.564044080173e-01
+ 1.050000000000e-06 2.566483695516e-01
+ 1.051000000000e-06 2.568923310859e-01
+ 1.052000000000e-06 2.571362926202e-01
+ 1.053000000000e-06 2.573802541544e-01
+ 1.054000000000e-06 2.576242156887e-01
+ 1.055000000000e-06 2.578681772230e-01
+ 1.056000000000e-06 2.581121387573e-01
+ 1.057000000000e-06 2.583561002916e-01
+ 1.058000000000e-06 2.586000618259e-01
+ 1.059000000000e-06 2.588440233602e-01
+ 1.060000000000e-06 2.590879848944e-01
+ 1.061000000000e-06 2.593319464287e-01
+ 1.062000000000e-06 2.595759079630e-01
+ 1.063000000000e-06 2.598198694973e-01
+ 1.064000000000e-06 2.600638310316e-01
+ 1.065000000000e-06 2.603077925659e-01
+ 1.066000000000e-06 2.605517541001e-01
+ 1.067000000000e-06 2.607957156344e-01
+ 1.068000000000e-06 2.610396771687e-01
+ 1.069000000000e-06 2.612836387030e-01
+ 1.070000000000e-06 2.615276002373e-01
+ 1.071000000000e-06 2.617715617716e-01
+ 1.072000000000e-06 2.620155233058e-01
+ 1.073000000000e-06 2.622594848401e-01
+ 1.074000000000e-06 2.625034463744e-01
+ 1.075000000000e-06 2.627474079087e-01
+ 1.076000000000e-06 2.629913694430e-01
+ 1.077000000000e-06 2.632353309773e-01
+ 1.078000000000e-06 2.634792925116e-01
+ 1.079000000000e-06 2.637232540458e-01
+ 1.080000000000e-06 2.639672155801e-01
+ 1.081000000000e-06 2.642111771144e-01
+ 1.082000000000e-06 2.644551386487e-01
+ 1.083000000000e-06 2.646991001830e-01
+ 1.084000000000e-06 2.649430617173e-01
+ 1.085000000000e-06 2.651870232515e-01
+ 1.086000000000e-06 2.654309847858e-01
+ 1.087000000000e-06 2.656749463201e-01
+ 1.088000000000e-06 2.659189078544e-01
+ 1.089000000000e-06 2.661628693887e-01
+ 1.090000000000e-06 2.664068309230e-01
+ 1.091000000000e-06 2.666507924572e-01
+ 1.092000000000e-06 2.668947539915e-01
+ 1.093000000000e-06 2.671387155258e-01
+ 1.094000000000e-06 2.673826770601e-01
+ 1.095000000000e-06 2.676266385944e-01
+ 1.096000000000e-06 2.678706001287e-01
+ 1.097000000000e-06 2.681145616629e-01
+ 1.098000000000e-06 2.683585231972e-01
+ 1.099000000000e-06 2.686024847315e-01
+ 1.100000000000e-06 2.688464462658e-01
+ 1.101000000000e-06 2.690904078001e-01
+ 1.102000000000e-06 2.693343693344e-01
+ 1.103000000000e-06 2.695783308687e-01
+ 1.104000000000e-06 2.698222924029e-01
+ 1.105000000000e-06 2.700662539372e-01
+ 1.106000000000e-06 2.703102154715e-01
+ 1.107000000000e-06 2.705541770058e-01
+ 1.108000000000e-06 2.707981385401e-01
+ 1.109000000000e-06 2.710421000744e-01
+ 1.110000000000e-06 2.712860616086e-01
+ 1.111000000000e-06 2.715300231429e-01
+ 1.112000000000e-06 2.717739846772e-01
+ 1.113000000000e-06 2.720179462115e-01
+ 1.114000000000e-06 2.722619077458e-01
+ 1.115000000000e-06 2.725058692801e-01
+ 1.116000000000e-06 2.727498308143e-01
+ 1.117000000000e-06 2.729937923486e-01
+ 1.118000000000e-06 2.732377538829e-01
+ 1.119000000000e-06 2.734817154172e-01
+ 1.120000000000e-06 2.737256769515e-01
+ 1.121000000000e-06 2.739696384858e-01
+ 1.122000000000e-06 2.742136000201e-01
+ 1.123000000000e-06 2.744575615543e-01
+ 1.124000000000e-06 2.747015230886e-01
+ 1.125000000000e-06 2.749454846229e-01
+ 1.126000000000e-06 2.751894461572e-01
+ 1.127000000000e-06 2.754334076915e-01
+ 1.128000000000e-06 2.756773692258e-01
+ 1.129000000000e-06 2.759213307600e-01
+ 1.130000000000e-06 2.761652922943e-01
+ 1.131000000000e-06 2.764092538286e-01
+ 1.132000000000e-06 2.766532153629e-01
+ 1.133000000000e-06 2.768971768972e-01
+ 1.134000000000e-06 2.771411384315e-01
+ 1.135000000000e-06 2.773850999657e-01
+ 1.136000000000e-06 2.776290615000e-01
+ 1.137000000000e-06 2.778730230343e-01
+ 1.138000000000e-06 2.781169845686e-01
+ 1.139000000000e-06 2.783609461029e-01
+ 1.140000000000e-06 2.786049076372e-01
+ 1.141000000000e-06 2.788488691714e-01
+ 1.142000000000e-06 2.790928307057e-01
+ 1.143000000000e-06 2.793367922400e-01
+ 1.144000000000e-06 2.795807537743e-01
+ 1.145000000000e-06 2.798247153086e-01
+ 1.146000000000e-06 2.800686768429e-01
+ 1.147000000000e-06 2.803126383772e-01
+ 1.148000000000e-06 2.805565999114e-01
+ 1.149000000000e-06 2.808005614457e-01
+ 1.150000000000e-06 2.810445229800e-01
+ 1.151000000000e-06 2.812884845143e-01
+ 1.152000000000e-06 2.815324460486e-01
+ 1.153000000000e-06 2.817764075829e-01
+ 1.154000000000e-06 2.820203691171e-01
+ 1.155000000000e-06 2.822643306514e-01
+ 1.156000000000e-06 2.825082921857e-01
+ 1.157000000000e-06 2.827522537200e-01
+ 1.158000000000e-06 2.829962152543e-01
+ 1.159000000000e-06 2.832401767886e-01
+ 1.160000000000e-06 2.834841383228e-01
+ 1.161000000000e-06 2.837280998571e-01
+ 1.162000000000e-06 2.839720613914e-01
+ 1.163000000000e-06 2.842160229257e-01
+ 1.164000000000e-06 2.844599844600e-01
+ 1.165000000000e-06 2.847039459943e-01
+ 1.166000000000e-06 2.849479075286e-01
+ 1.167000000000e-06 2.851918690628e-01
+ 1.168000000000e-06 2.854358305971e-01
+ 1.169000000000e-06 2.856797921314e-01
+ 1.170000000000e-06 2.859237536657e-01
+ 1.171000000000e-06 2.861677152000e-01
+ 1.172000000000e-06 2.864116767343e-01
+ 1.173000000000e-06 2.866556382685e-01
+ 1.174000000000e-06 2.868995998028e-01
+ 1.175000000000e-06 2.871435613371e-01
+ 1.176000000000e-06 2.873875228714e-01
+ 1.177000000000e-06 2.876314844057e-01
+ 1.178000000000e-06 2.878754459400e-01
+ 1.179000000000e-06 2.881194074742e-01
+ 1.180000000000e-06 2.883633690085e-01
+ 1.181000000000e-06 2.886073305428e-01
+ 1.182000000000e-06 2.888512920771e-01
+ 1.183000000000e-06 2.890952536114e-01
+ 1.184000000000e-06 2.893392151457e-01
+ 1.185000000000e-06 2.895831766800e-01
+ 1.186000000000e-06 2.898271382142e-01
+ 1.187000000000e-06 2.900710997485e-01
+ 1.188000000000e-06 2.903150612828e-01
+ 1.189000000000e-06 2.905590228171e-01
+ 1.190000000000e-06 2.908029843514e-01
+ 1.191000000000e-06 2.910469458857e-01
+ 1.192000000000e-06 2.912909074199e-01
+ 1.193000000000e-06 2.915348689542e-01
+ 1.194000000000e-06 2.917788304885e-01
+ 1.195000000000e-06 2.920227920228e-01
+ 1.196000000000e-06 2.922667535571e-01
+ 1.197000000000e-06 2.925107150914e-01
+ 1.198000000000e-06 2.927546766256e-01
+ 1.199000000000e-06 2.929986381599e-01
+ 1.200000000000e-06 2.932425996942e-01
+ 1.201000000000e-06 2.934865612285e-01
+ 1.202000000000e-06 2.937305227628e-01
+ 1.203000000000e-06 2.939744842971e-01
+ 1.204000000000e-06 2.942184458313e-01
+ 1.205000000000e-06 2.944624073656e-01
+ 1.206000000000e-06 2.947063688999e-01
+ 1.207000000000e-06 2.949503304342e-01
+ 1.208000000000e-06 2.951942919685e-01
+ 1.209000000000e-06 2.954382535028e-01
+ 1.210000000000e-06 2.956822150371e-01
+ 1.211000000000e-06 2.959261765713e-01
+ 1.212000000000e-06 2.961701381056e-01
+ 1.213000000000e-06 2.964140996399e-01
+ 1.214000000000e-06 2.966580611742e-01
+ 1.215000000000e-06 2.969020227085e-01
+ 1.216000000000e-06 2.971459842428e-01
+ 1.217000000000e-06 2.973899457770e-01
+ 1.218000000000e-06 2.976339073113e-01
+ 1.219000000000e-06 2.978778688456e-01
+ 1.220000000000e-06 2.981218303799e-01
+ 1.221000000000e-06 2.983657919142e-01
+ 1.222000000000e-06 2.986097534485e-01
+ 1.223000000000e-06 2.988537149827e-01
+ 1.224000000000e-06 2.990976765170e-01
+ 1.225000000000e-06 2.993416380513e-01
+ 1.226000000000e-06 2.995855995856e-01
+ 1.227000000000e-06 2.998295611199e-01
+ 1.228000000000e-06 3.000735226542e-01
+ 1.229000000000e-06 3.003174841885e-01
+ 1.230000000000e-06 3.005614457227e-01
+ 1.231000000000e-06 3.008054072570e-01
+ 1.232000000000e-06 3.010493687913e-01
+ 1.233000000000e-06 3.012933303256e-01
+ 1.234000000000e-06 3.015372918599e-01
+ 1.235000000000e-06 3.017812533942e-01
+ 1.236000000000e-06 3.020252149284e-01
+ 1.237000000000e-06 3.022691764627e-01
+ 1.238000000000e-06 3.025131379970e-01
+ 1.239000000000e-06 3.027570995313e-01
+ 1.240000000000e-06 3.030010610656e-01
+ 1.241000000000e-06 3.032450225999e-01
+ 1.242000000000e-06 3.034889841341e-01
+ 1.243000000000e-06 3.037329456684e-01
+ 1.244000000000e-06 3.039769072027e-01
+ 1.245000000000e-06 3.042208687370e-01
+ 1.246000000000e-06 3.044648302713e-01
+ 1.247000000000e-06 3.047087918056e-01
+ 1.248000000000e-06 3.049527533399e-01
+ 1.249000000000e-06 3.051967148741e-01
+ 1.250000000000e-06 3.054406764084e-01
+ 1.251000000000e-06 3.056846379427e-01
+ 1.252000000000e-06 3.059285994770e-01
+ 1.253000000000e-06 3.061725610113e-01
+ 1.254000000000e-06 3.064165225456e-01
+ 1.255000000000e-06 3.066604840798e-01
+ 1.256000000000e-06 3.069044456141e-01
+ 1.257000000000e-06 3.071484071484e-01
+ 1.258000000000e-06 3.073923686827e-01
+ 1.259000000000e-06 3.076363302170e-01
+ 1.260000000000e-06 3.078802917513e-01
+ 1.261000000000e-06 3.081242532855e-01
+ 1.262000000000e-06 3.083682148198e-01
+ 1.263000000000e-06 3.086121763541e-01
+ 1.264000000000e-06 3.088561378884e-01
+ 1.265000000000e-06 3.091000994227e-01
+ 1.266000000000e-06 3.093440609570e-01
+ 1.267000000000e-06 3.095880224912e-01
+ 1.268000000000e-06 3.098319840255e-01
+ 1.269000000000e-06 3.100759455598e-01
+ 1.270000000000e-06 3.103199070941e-01
+ 1.271000000000e-06 3.105638686284e-01
+ 1.272000000000e-06 3.108078301627e-01
+ 1.273000000000e-06 3.110517916970e-01
+ 1.274000000000e-06 3.112957532312e-01
+ 1.275000000000e-06 3.115397147655e-01
+ 1.276000000000e-06 3.117836762998e-01
+ 1.277000000000e-06 3.120276378341e-01
+ 1.278000000000e-06 3.122715993684e-01
+ 1.279000000000e-06 3.125155609027e-01
+ 1.280000000000e-06 3.127595224369e-01
+ 1.281000000000e-06 3.130034839712e-01
+ 1.282000000000e-06 3.132474455055e-01
+ 1.283000000000e-06 3.134914070398e-01
+ 1.284000000000e-06 3.137353685741e-01
+ 1.285000000000e-06 3.139793301084e-01
+ 1.286000000000e-06 3.142232916426e-01
+ 1.287000000000e-06 3.144672531769e-01
+ 1.288000000000e-06 3.147112147112e-01
+ 1.289000000000e-06 3.149551762455e-01
+ 1.290000000000e-06 3.151991377798e-01
+ 1.291000000000e-06 3.154430993141e-01
+ 1.292000000000e-06 3.156870608484e-01
+ 1.293000000000e-06 3.159310223826e-01
+ 1.294000000000e-06 3.161749839169e-01
+ 1.295000000000e-06 3.164189454512e-01
+ 1.296000000000e-06 3.166629069855e-01
+ 1.297000000000e-06 3.169068685198e-01
+ 1.298000000000e-06 3.171508300541e-01
+ 1.299000000000e-06 3.173947915883e-01
+ 1.300000000000e-06 3.176387531226e-01
+ 1.301000000000e-06 3.178827146569e-01
+ 1.302000000000e-06 3.181266761912e-01
+ 1.303000000000e-06 3.183706377255e-01
+ 1.304000000000e-06 3.186145992598e-01
+ 1.305000000000e-06 3.188585607940e-01
+ 1.306000000000e-06 3.191025223283e-01
+ 1.307000000000e-06 3.193464838626e-01
+ 1.308000000000e-06 3.195904453969e-01
+ 1.309000000000e-06 3.198344069312e-01
+ 1.310000000000e-06 3.200783684655e-01
+ 1.311000000000e-06 3.203223299997e-01
+ 1.312000000000e-06 3.205662915340e-01
+ 1.313000000000e-06 3.208102530683e-01
+ 1.314000000000e-06 3.210542146026e-01
+ 1.315000000000e-06 3.212981761369e-01
+ 1.316000000000e-06 3.215421376712e-01
+ 1.317000000000e-06 3.217860992055e-01
+ 1.318000000000e-06 3.220300607397e-01
+ 1.319000000000e-06 3.222740222740e-01
+ 1.320000000000e-06 3.225179838083e-01
+ 1.321000000000e-06 3.227619453426e-01
+ 1.322000000000e-06 3.230059068769e-01
+ 1.323000000000e-06 3.232498684112e-01
+ 1.324000000000e-06 3.234938299454e-01
+ 1.325000000000e-06 3.237377914797e-01
+ 1.326000000000e-06 3.239817530140e-01
+ 1.327000000000e-06 3.242257145483e-01
+ 1.328000000000e-06 3.244696760826e-01
+ 1.329000000000e-06 3.247136376169e-01
+ 1.330000000000e-06 3.249575991511e-01
+ 1.331000000000e-06 3.252015606854e-01
+ 1.332000000000e-06 3.254455222197e-01
+ 1.333000000000e-06 3.256894837540e-01
+ 1.334000000000e-06 3.259334452883e-01
+ 1.335000000000e-06 3.261774068226e-01
+ 1.336000000000e-06 3.264213683569e-01
+ 1.337000000000e-06 3.266653298911e-01
+ 1.338000000000e-06 3.269092914254e-01
+ 1.339000000000e-06 3.271532529597e-01
+ 1.340000000000e-06 3.273972144940e-01
+ 1.341000000000e-06 3.276411760283e-01
+ 1.342000000000e-06 3.278851375626e-01
+ 1.343000000000e-06 3.281290990968e-01
+ 1.344000000000e-06 3.283730606311e-01
+ 1.345000000000e-06 3.286170221654e-01
+ 1.346000000000e-06 3.288609836997e-01
+ 1.347000000000e-06 3.291049452340e-01
+ 1.348000000000e-06 3.293489067683e-01
+ 1.349000000000e-06 3.295928683025e-01
+ 1.350000000000e-06 3.298368298368e-01
+ 1.351000000000e-06 3.300807913711e-01
+ 1.352000000000e-06 3.303247529054e-01
+ 1.353000000000e-06 3.305687144397e-01
+ 1.354000000000e-06 3.308126759740e-01
+ 1.355000000000e-06 3.310566375083e-01
+ 1.356000000000e-06 3.313005990425e-01
+ 1.357000000000e-06 3.315445605768e-01
+ 1.358000000000e-06 3.317885221111e-01
+ 1.359000000000e-06 3.320324836454e-01
+ 1.360000000000e-06 3.322764451797e-01
+ 1.361000000000e-06 3.325204067140e-01
+ 1.362000000000e-06 3.327643682482e-01
+ 1.363000000000e-06 3.330083297825e-01
+ 1.364000000000e-06 3.332522913168e-01
+ 1.365000000000e-06 3.334962528511e-01
+ 1.366000000000e-06 3.337402143854e-01
+ 1.367000000000e-06 3.339841759197e-01
+ 1.368000000000e-06 3.342281374539e-01
+ 1.369000000000e-06 3.344720989882e-01
+ 1.370000000000e-06 3.347160605225e-01
+ 1.371000000000e-06 3.349600220568e-01
+ 1.372000000000e-06 3.352039835911e-01
+ 1.373000000000e-06 3.354479451254e-01
+ 1.374000000000e-06 3.356919066596e-01
+ 1.375000000000e-06 3.359358681939e-01
+ 1.376000000000e-06 3.361798297282e-01
+ 1.377000000000e-06 3.364237912625e-01
+ 1.378000000000e-06 3.366677527968e-01
+ 1.379000000000e-06 3.369117143311e-01
+ 1.380000000000e-06 3.371556758654e-01
+ 1.381000000000e-06 3.373996373996e-01
+ 1.382000000000e-06 3.376435989339e-01
+ 1.383000000000e-06 3.378875604682e-01
+ 1.384000000000e-06 3.381315220025e-01
+ 1.385000000000e-06 3.383754835368e-01
+ 1.386000000000e-06 3.386194450711e-01
+ 1.387000000000e-06 3.388634066053e-01
+ 1.388000000000e-06 3.391073681396e-01
+ 1.389000000000e-06 3.393513296739e-01
+ 1.390000000000e-06 3.395952912082e-01
+ 1.391000000000e-06 3.398392527425e-01
+ 1.392000000000e-06 3.400832142768e-01
+ 1.393000000000e-06 3.403271758110e-01
+ 1.394000000000e-06 3.405711373453e-01
+ 1.395000000000e-06 3.408150988796e-01
+ 1.396000000000e-06 3.410590604139e-01
+ 1.397000000000e-06 3.413030219482e-01
+ 1.398000000000e-06 3.415469834825e-01
+ 1.399000000000e-06 3.417909450168e-01
+ 1.400000000000e-06 3.420349065510e-01
+ 1.401000000000e-06 3.422788680853e-01
+ 1.402000000000e-06 3.425228296196e-01
+ 1.403000000000e-06 3.427667911539e-01
+ 1.404000000000e-06 3.430107526882e-01
+ 1.405000000000e-06 3.432547142225e-01
+ 1.406000000000e-06 3.434986757567e-01
+ 1.407000000000e-06 3.437426372910e-01
+ 1.408000000000e-06 3.439865988253e-01
+ 1.409000000000e-06 3.442305603596e-01
+ 1.410000000000e-06 3.444745218939e-01
+ 1.411000000000e-06 3.447184834282e-01
+ 1.412000000000e-06 3.449624449624e-01
+ 1.413000000000e-06 3.452064064967e-01
+ 1.414000000000e-06 3.454503680310e-01
+ 1.415000000000e-06 3.456943295653e-01
+ 1.416000000000e-06 3.459382910996e-01
+ 1.417000000000e-06 3.461822526339e-01
+ 1.418000000000e-06 3.464262141681e-01
+ 1.419000000000e-06 3.466701757024e-01
+ 1.420000000000e-06 3.469141372367e-01
+ 1.421000000000e-06 3.471580987710e-01
+ 1.422000000000e-06 3.474020603053e-01
+ 1.423000000000e-06 3.476460218396e-01
+ 1.424000000000e-06 3.478899833739e-01
+ 1.425000000000e-06 3.481339449081e-01
+ 1.426000000000e-06 3.483779064424e-01
+ 1.427000000000e-06 3.486218679767e-01
+ 1.428000000000e-06 3.488658295110e-01
+ 1.429000000000e-06 3.491097910453e-01
+ 1.430000000000e-06 3.493537525796e-01
+ 1.431000000000e-06 3.495977141138e-01
+ 1.432000000000e-06 3.498416756481e-01
+ 1.433000000000e-06 3.500856371824e-01
+ 1.434000000000e-06 3.503295987167e-01
+ 1.435000000000e-06 3.505735602510e-01
+ 1.436000000000e-06 3.508175217853e-01
+ 1.437000000000e-06 3.510614833195e-01
+ 1.438000000000e-06 3.513054448538e-01
+ 1.439000000000e-06 3.515494063881e-01
+ 1.440000000000e-06 3.517933679224e-01
+ 1.441000000000e-06 3.520373294567e-01
+ 1.442000000000e-06 3.522812909910e-01
+ 1.443000000000e-06 3.525252525253e-01
+ 1.444000000000e-06 3.527692140595e-01
+ 1.445000000000e-06 3.530131755938e-01
+ 1.446000000000e-06 3.532571371281e-01
+ 1.447000000000e-06 3.535010986624e-01
+ 1.448000000000e-06 3.537450601967e-01
+ 1.449000000000e-06 3.539890217310e-01
+ 1.450000000000e-06 3.542329832652e-01
+ 1.451000000000e-06 3.544769447995e-01
+ 1.452000000000e-06 3.547209063338e-01
+ 1.453000000000e-06 3.549648678681e-01
+ 1.454000000000e-06 3.552088294024e-01
+ 1.455000000000e-06 3.554527909367e-01
+ 1.456000000000e-06 3.556967524709e-01
+ 1.457000000000e-06 3.559407140052e-01
+ 1.458000000000e-06 3.561846755395e-01
+ 1.459000000000e-06 3.564286370738e-01
+ 1.460000000000e-06 3.566725986081e-01
+ 1.461000000000e-06 3.569165601424e-01
+ 1.462000000000e-06 3.571605216767e-01
+ 1.463000000000e-06 3.574044832109e-01
+ 1.464000000000e-06 3.576484447452e-01
+ 1.465000000000e-06 3.578924062795e-01
+ 1.466000000000e-06 3.581363678138e-01
+ 1.467000000000e-06 3.583803293481e-01
+ 1.468000000000e-06 3.586242908824e-01
+ 1.469000000000e-06 3.588682524166e-01
+ 1.470000000000e-06 3.591122139509e-01
+ 1.471000000000e-06 3.593561754852e-01
+ 1.472000000000e-06 3.596001370195e-01
+ 1.473000000000e-06 3.598440985538e-01
+ 1.474000000000e-06 3.600880600881e-01
+ 1.475000000000e-06 3.603320216223e-01
+ 1.476000000000e-06 3.605759831566e-01
+ 1.477000000000e-06 3.608199446909e-01
+ 1.478000000000e-06 3.610639062252e-01
+ 1.479000000000e-06 3.613078677595e-01
+ 1.480000000000e-06 3.615518292938e-01
+ 1.481000000000e-06 3.617957908280e-01
+ 1.482000000000e-06 3.620397523623e-01
+ 1.483000000000e-06 3.622837138966e-01
+ 1.484000000000e-06 3.625276754309e-01
+ 1.485000000000e-06 3.627716369652e-01
+ 1.486000000000e-06 3.630155984995e-01
+ 1.487000000000e-06 3.632595600338e-01
+ 1.488000000000e-06 3.635035215680e-01
+ 1.489000000000e-06 3.637474831023e-01
+ 1.490000000000e-06 3.639914446366e-01
+ 1.491000000000e-06 3.642354061709e-01
+ 1.492000000000e-06 3.644793677052e-01
+ 1.493000000000e-06 3.647233292395e-01
+ 1.494000000000e-06 3.649672907737e-01
+ 1.495000000000e-06 3.652112523080e-01
+ 1.496000000000e-06 3.654552138423e-01
+ 1.497000000000e-06 3.656991753766e-01
+ 1.498000000000e-06 3.659431369109e-01
+ 1.499000000000e-06 3.661870984452e-01
+ 1.500000000000e-06 3.664310599794e-01
+ 1.501000000000e-06 3.666750215137e-01
+ 1.502000000000e-06 3.669189830480e-01
+ 1.503000000000e-06 3.671629445823e-01
+ 1.504000000000e-06 3.674069061166e-01
+ 1.505000000000e-06 3.676508676509e-01
+ 1.506000000000e-06 3.678948291852e-01
+ 1.507000000000e-06 3.681387907194e-01
+ 1.508000000000e-06 3.683827522537e-01
+ 1.509000000000e-06 3.686267137880e-01
+ 1.510000000000e-06 3.688706753223e-01
+ 1.511000000000e-06 3.691146368566e-01
+ 1.512000000000e-06 3.693585983909e-01
+ 1.513000000000e-06 3.696025599251e-01
+ 1.514000000000e-06 3.698465214594e-01
+ 1.515000000000e-06 3.700904829937e-01
+ 1.516000000000e-06 3.703344445280e-01
+ 1.517000000000e-06 3.705784060623e-01
+ 1.518000000000e-06 3.708223675966e-01
+ 1.519000000000e-06 3.710663291308e-01
+ 1.520000000000e-06 3.713102906651e-01
+ 1.521000000000e-06 3.715542521994e-01
+ 1.522000000000e-06 3.717982137337e-01
+ 1.523000000000e-06 3.720421752680e-01
+ 1.524000000000e-06 3.722861368023e-01
+ 1.525000000000e-06 3.725300983365e-01
+ 1.526000000000e-06 3.727740598708e-01
+ 1.527000000000e-06 3.730180214051e-01
+ 1.528000000000e-06 3.732619829394e-01
+ 1.529000000000e-06 3.735059444737e-01
+ 1.530000000000e-06 3.737499060080e-01
+ 1.531000000000e-06 3.739938675423e-01
+ 1.532000000000e-06 3.742378290765e-01
+ 1.533000000000e-06 3.744817906108e-01
+ 1.534000000000e-06 3.747257521451e-01
+ 1.535000000000e-06 3.749697136794e-01
+ 1.536000000000e-06 3.752136752137e-01
+ 1.537000000000e-06 3.754576367480e-01
+ 1.538000000000e-06 3.757015982822e-01
+ 1.539000000000e-06 3.759455598165e-01
+ 1.540000000000e-06 3.761895213508e-01
+ 1.541000000000e-06 3.764334828851e-01
+ 1.542000000000e-06 3.766774444194e-01
+ 1.543000000000e-06 3.769214059537e-01
+ 1.544000000000e-06 3.771653674879e-01
+ 1.545000000000e-06 3.774093290222e-01
+ 1.546000000000e-06 3.776532905565e-01
+ 1.547000000000e-06 3.778972520908e-01
+ 1.548000000000e-06 3.781412136251e-01
+ 1.549000000000e-06 3.783851751594e-01
+ 1.550000000000e-06 3.786291366937e-01
+ 1.551000000000e-06 3.788730982279e-01
+ 1.552000000000e-06 3.791170597622e-01
+ 1.553000000000e-06 3.793610212965e-01
+ 1.554000000000e-06 3.796049828308e-01
+ 1.555000000000e-06 3.798489443651e-01
+ 1.556000000000e-06 3.800929058994e-01
+ 1.557000000000e-06 3.803368674336e-01
+ 1.558000000000e-06 3.805808289679e-01
+ 1.559000000000e-06 3.808247905022e-01
+ 1.560000000000e-06 3.810687520365e-01
+ 1.561000000000e-06 3.813127135708e-01
+ 1.562000000000e-06 3.815566751051e-01
+ 1.563000000000e-06 3.818006366393e-01
+ 1.564000000000e-06 3.820445981736e-01
+ 1.565000000000e-06 3.822885597079e-01
+ 1.566000000000e-06 3.825325212422e-01
+ 1.567000000000e-06 3.827764827765e-01
+ 1.568000000000e-06 3.830204443108e-01
+ 1.569000000000e-06 3.832644058451e-01
+ 1.570000000000e-06 3.835083673793e-01
+ 1.571000000000e-06 3.837523289136e-01
+ 1.572000000000e-06 3.839962904479e-01
+ 1.573000000000e-06 3.842402519822e-01
+ 1.574000000000e-06 3.844842135165e-01
+ 1.575000000000e-06 3.847281750508e-01
+ 1.576000000000e-06 3.849721365850e-01
+ 1.577000000000e-06 3.852160981193e-01
+ 1.578000000000e-06 3.854600596536e-01
+ 1.579000000000e-06 3.857040211879e-01
+ 1.580000000000e-06 3.859479827222e-01
+ 1.581000000000e-06 3.861919442565e-01
+ 1.582000000000e-06 3.864359057907e-01
+ 1.583000000000e-06 3.866798673250e-01
+ 1.584000000000e-06 3.869238288593e-01
+ 1.585000000000e-06 3.871677903936e-01
+ 1.586000000000e-06 3.874117519279e-01
+ 1.587000000000e-06 3.876557134622e-01
+ 1.588000000000e-06 3.878996749964e-01
+ 1.589000000000e-06 3.881436365307e-01
+ 1.590000000000e-06 3.883875980650e-01
+ 1.591000000000e-06 3.886315595993e-01
+ 1.592000000000e-06 3.888755211336e-01
+ 1.593000000000e-06 3.891194826679e-01
+ 1.594000000000e-06 3.893634442022e-01
+ 1.595000000000e-06 3.896074057364e-01
+ 1.596000000000e-06 3.898513672707e-01
+ 1.597000000000e-06 3.900953288050e-01
+ 1.598000000000e-06 3.903392903393e-01
+ 1.599000000000e-06 3.905832518736e-01
+ 1.600000000000e-06 3.908272134079e-01
+ 1.601000000000e-06 3.910711749421e-01
+ 1.602000000000e-06 3.913151364764e-01
+ 1.603000000000e-06 3.915590980107e-01
+ 1.604000000000e-06 3.918030595450e-01
+ 1.605000000000e-06 3.920470210793e-01
+ 1.606000000000e-06 3.922909826136e-01
+ 1.607000000000e-06 3.925349441478e-01
+ 1.608000000000e-06 3.927789056821e-01
+ 1.609000000000e-06 3.930228672164e-01
+ 1.610000000000e-06 3.932668287507e-01
+ 1.611000000000e-06 3.935107902850e-01
+ 1.612000000000e-06 3.937547518193e-01
+ 1.613000000000e-06 3.939987133536e-01
+ 1.614000000000e-06 3.942426748878e-01
+ 1.615000000000e-06 3.944866364221e-01
+ 1.616000000000e-06 3.947305979564e-01
+ 1.617000000000e-06 3.949745594907e-01
+ 1.618000000000e-06 3.952185210250e-01
+ 1.619000000000e-06 3.954624825593e-01
+ 1.620000000000e-06 3.957064440935e-01
+ 1.621000000000e-06 3.959504056278e-01
+ 1.622000000000e-06 3.961943671621e-01
+ 1.623000000000e-06 3.964383286964e-01
+ 1.624000000000e-06 3.966822902307e-01
+ 1.625000000000e-06 3.969262517650e-01
+ 1.626000000000e-06 3.971702132992e-01
+ 1.627000000000e-06 3.974141748335e-01
+ 1.628000000000e-06 3.976581363678e-01
+ 1.629000000000e-06 3.979020979021e-01
+ 1.630000000000e-06 3.981460594364e-01
+ 1.631000000000e-06 3.983900209707e-01
+ 1.632000000000e-06 3.986339825050e-01
+ 1.633000000000e-06 3.988779440392e-01
+ 1.634000000000e-06 3.991219055735e-01
+ 1.635000000000e-06 3.993658671078e-01
+ 1.636000000000e-06 3.996098286421e-01
+ 1.637000000000e-06 3.998537901764e-01
+ 1.638000000000e-06 4.000977517107e-01
+ 1.639000000000e-06 4.003417132449e-01
+ 1.640000000000e-06 4.005856747792e-01
+ 1.641000000000e-06 4.008296363135e-01
+ 1.642000000000e-06 4.010735978478e-01
+ 1.643000000000e-06 4.013175593821e-01
+ 1.644000000000e-06 4.015615209164e-01
+ 1.645000000000e-06 4.018054824506e-01
+ 1.646000000000e-06 4.020494439849e-01
+ 1.647000000000e-06 4.022934055192e-01
+ 1.648000000000e-06 4.025373670535e-01
+ 1.649000000000e-06 4.027813285878e-01
+ 1.650000000000e-06 4.030252901221e-01
+ 1.651000000000e-06 4.032692516563e-01
+ 1.652000000000e-06 4.035132131906e-01
+ 1.653000000000e-06 4.037571747249e-01
+ 1.654000000000e-06 4.040011362592e-01
+ 1.655000000000e-06 4.042450977935e-01
+ 1.656000000000e-06 4.044890593278e-01
+ 1.657000000000e-06 4.047330208621e-01
+ 1.658000000000e-06 4.049769823963e-01
+ 1.659000000000e-06 4.052209439306e-01
+ 1.660000000000e-06 4.054649054649e-01
+ 1.661000000000e-06 4.057088669992e-01
+ 1.662000000000e-06 4.059528285335e-01
+ 1.663000000000e-06 4.061967900678e-01
+ 1.664000000000e-06 4.064407516020e-01
+ 1.665000000000e-06 4.066847131363e-01
+ 1.666000000000e-06 4.069286746706e-01
+ 1.667000000000e-06 4.071726362049e-01
+ 1.668000000000e-06 4.074165977392e-01
+ 1.669000000000e-06 4.076605592735e-01
+ 1.670000000000e-06 4.079045208077e-01
+ 1.671000000000e-06 4.081484823420e-01
+ 1.672000000000e-06 4.083924438763e-01
+ 1.673000000000e-06 4.086364054106e-01
+ 1.674000000000e-06 4.088803669449e-01
+ 1.675000000000e-06 4.091243284792e-01
+ 1.676000000000e-06 4.093682900135e-01
+ 1.677000000000e-06 4.096122515477e-01
+ 1.678000000000e-06 4.098562130820e-01
+ 1.679000000000e-06 4.101001746163e-01
+ 1.680000000000e-06 4.103441361506e-01
+ 1.681000000000e-06 4.105880976849e-01
+ 1.682000000000e-06 4.108320592192e-01
+ 1.683000000000e-06 4.110760207534e-01
+ 1.684000000000e-06 4.113199822877e-01
+ 1.685000000000e-06 4.115639438220e-01
+ 1.686000000000e-06 4.118079053563e-01
+ 1.687000000000e-06 4.120518668906e-01
+ 1.688000000000e-06 4.122958284249e-01
+ 1.689000000000e-06 4.125397899591e-01
+ 1.690000000000e-06 4.127837514934e-01
+ 1.691000000000e-06 4.130277130277e-01
+ 1.692000000000e-06 4.132716745620e-01
+ 1.693000000000e-06 4.135156360963e-01
+ 1.694000000000e-06 4.137595976306e-01
+ 1.695000000000e-06 4.140035591648e-01
+ 1.696000000000e-06 4.142475206991e-01
+ 1.697000000000e-06 4.144914822334e-01
+ 1.698000000000e-06 4.147354437677e-01
+ 1.699000000000e-06 4.149794053020e-01
+ 1.700000000000e-06 4.152233668363e-01
+ 1.701000000000e-06 4.154673283706e-01
+ 1.702000000000e-06 4.157112899048e-01
+ 1.703000000000e-06 4.159552514391e-01
+ 1.704000000000e-06 4.161992129734e-01
+ 1.705000000000e-06 4.164431745077e-01
+ 1.706000000000e-06 4.166871360420e-01
+ 1.707000000000e-06 4.169310975763e-01
+ 1.708000000000e-06 4.171750591105e-01
+ 1.709000000000e-06 4.174190206448e-01
+ 1.710000000000e-06 4.176629821791e-01
+ 1.711000000000e-06 4.179069437134e-01
+ 1.712000000000e-06 4.181509052477e-01
+ 1.713000000000e-06 4.183948667820e-01
+ 1.714000000000e-06 4.186388283162e-01
+ 1.715000000000e-06 4.188827898505e-01
+ 1.716000000000e-06 4.191267513848e-01
+ 1.717000000000e-06 4.193707129191e-01
+ 1.718000000000e-06 4.196146744534e-01
+ 1.719000000000e-06 4.198586359877e-01
+ 1.720000000000e-06 4.201025975220e-01
+ 1.721000000000e-06 4.203465590562e-01
+ 1.722000000000e-06 4.205905205905e-01
+ 1.723000000000e-06 4.208344821248e-01
+ 1.724000000000e-06 4.210784436591e-01
+ 1.725000000000e-06 4.213224051934e-01
+ 1.726000000000e-06 4.215663667277e-01
+ 1.727000000000e-06 4.218103282619e-01
+ 1.728000000000e-06 4.220542897962e-01
+ 1.729000000000e-06 4.222982513305e-01
+ 1.730000000000e-06 4.225422128648e-01
+ 1.731000000000e-06 4.227861743991e-01
+ 1.732000000000e-06 4.230301359334e-01
+ 1.733000000000e-06 4.232740974676e-01
+ 1.734000000000e-06 4.235180590019e-01
+ 1.735000000000e-06 4.237620205362e-01
+ 1.736000000000e-06 4.240059820705e-01
+ 1.737000000000e-06 4.242499436048e-01
+ 1.738000000000e-06 4.244939051391e-01
+ 1.739000000000e-06 4.247378666734e-01
+ 1.740000000000e-06 4.249818282076e-01
+ 1.741000000000e-06 4.252257897419e-01
+ 1.742000000000e-06 4.254697512762e-01
+ 1.743000000000e-06 4.257137128105e-01
+ 1.744000000000e-06 4.259576743448e-01
+ 1.745000000000e-06 4.262016358791e-01
+ 1.746000000000e-06 4.264455974133e-01
+ 1.747000000000e-06 4.266895589476e-01
+ 1.748000000000e-06 4.269335204819e-01
+ 1.749000000000e-06 4.271774820162e-01
+ 1.750000000000e-06 4.274214435505e-01
+ 1.751000000000e-06 4.276654050848e-01
+ 1.752000000000e-06 4.279093666190e-01
+ 1.753000000000e-06 4.281533281533e-01
+ 1.754000000000e-06 4.283972896876e-01
+ 1.755000000000e-06 4.286412512219e-01
+ 1.756000000000e-06 4.288852127562e-01
+ 1.757000000000e-06 4.291291742905e-01
+ 1.758000000000e-06 4.293731358247e-01
+ 1.759000000000e-06 4.296170973590e-01
+ 1.760000000000e-06 4.298610588933e-01
+ 1.761000000000e-06 4.301050204276e-01
+ 1.762000000000e-06 4.303489819619e-01
+ 1.763000000000e-06 4.305929434962e-01
+ 1.764000000000e-06 4.308369050305e-01
+ 1.765000000000e-06 4.310808665647e-01
+ 1.766000000000e-06 4.313248280990e-01
+ 1.767000000000e-06 4.315687896333e-01
+ 1.768000000000e-06 4.318127511676e-01
+ 1.769000000000e-06 4.320567127019e-01
+ 1.770000000000e-06 4.323006742362e-01
+ 1.771000000000e-06 4.325446357704e-01
+ 1.772000000000e-06 4.327885973047e-01
+ 1.773000000000e-06 4.330325588390e-01
+ 1.774000000000e-06 4.332765203733e-01
+ 1.775000000000e-06 4.335204819076e-01
+ 1.776000000000e-06 4.337644434419e-01
+ 1.777000000000e-06 4.340084049761e-01
+ 1.778000000000e-06 4.342523665104e-01
+ 1.779000000000e-06 4.344963280447e-01
+ 1.780000000000e-06 4.347402895790e-01
+ 1.781000000000e-06 4.349842511133e-01
+ 1.782000000000e-06 4.352282126476e-01
+ 1.783000000000e-06 4.354721741819e-01
+ 1.784000000000e-06 4.357161357161e-01
+ 1.785000000000e-06 4.359600972504e-01
+ 1.786000000000e-06 4.362040587847e-01
+ 1.787000000000e-06 4.364480203190e-01
+ 1.788000000000e-06 4.366919818533e-01
+ 1.789000000000e-06 4.369359433876e-01
+ 1.790000000000e-06 4.371799049218e-01
+ 1.791000000000e-06 4.374238664561e-01
+ 1.792000000000e-06 4.376678279904e-01
+ 1.793000000000e-06 4.379117895247e-01
+ 1.794000000000e-06 4.381557510590e-01
+ 1.795000000000e-06 4.383997125933e-01
+ 1.796000000000e-06 4.386436741275e-01
+ 1.797000000000e-06 4.388876356618e-01
+ 1.798000000000e-06 4.391315971961e-01
+ 1.799000000000e-06 4.393755587304e-01
+ 1.800000000000e-06 4.396195202647e-01
+ 1.801000000000e-06 4.398634817990e-01
+ 1.802000000000e-06 4.401074433332e-01
+ 1.803000000000e-06 4.403514048675e-01
+ 1.804000000000e-06 4.405953664018e-01
+ 1.805000000000e-06 4.408393279361e-01
+ 1.806000000000e-06 4.410832894704e-01
+ 1.807000000000e-06 4.413272510047e-01
+ 1.808000000000e-06 4.415712125390e-01
+ 1.809000000000e-06 4.418151740732e-01
+ 1.810000000000e-06 4.420591356075e-01
+ 1.811000000000e-06 4.423030971418e-01
+ 1.812000000000e-06 4.425470586761e-01
+ 1.813000000000e-06 4.427910202104e-01
+ 1.814000000000e-06 4.430349817447e-01
+ 1.815000000000e-06 4.432789432789e-01
+ 1.816000000000e-06 4.435229048132e-01
+ 1.817000000000e-06 4.437668663475e-01
+ 1.818000000000e-06 4.440108278818e-01
+ 1.819000000000e-06 4.442547894161e-01
+ 1.820000000000e-06 4.444987509504e-01
+ 1.821000000000e-06 4.447427124846e-01
+ 1.822000000000e-06 4.449866740189e-01
+ 1.823000000000e-06 4.452306355532e-01
+ 1.824000000000e-06 4.454745970875e-01
+ 1.825000000000e-06 4.457185586218e-01
+ 1.826000000000e-06 4.459625201561e-01
+ 1.827000000000e-06 4.462064816904e-01
+ 1.828000000000e-06 4.464504432246e-01
+ 1.829000000000e-06 4.466944047589e-01
+ 1.830000000000e-06 4.469383662932e-01
+ 1.831000000000e-06 4.471823278275e-01
+ 1.832000000000e-06 4.474262893618e-01
+ 1.833000000000e-06 4.476702508961e-01
+ 1.834000000000e-06 4.479142124303e-01
+ 1.835000000000e-06 4.481581739646e-01
+ 1.836000000000e-06 4.484021354989e-01
+ 1.837000000000e-06 4.486460970332e-01
+ 1.838000000000e-06 4.488900585675e-01
+ 1.839000000000e-06 4.491340201018e-01
+ 1.840000000000e-06 4.493779816360e-01
+ 1.841000000000e-06 4.496219431703e-01
+ 1.842000000000e-06 4.498659047046e-01
+ 1.843000000000e-06 4.501098662389e-01
+ 1.844000000000e-06 4.503538277732e-01
+ 1.845000000000e-06 4.505977893075e-01
+ 1.846000000000e-06 4.508417508418e-01
+ 1.847000000000e-06 4.510857123760e-01
+ 1.848000000000e-06 4.513296739103e-01
+ 1.849000000000e-06 4.515736354446e-01
+ 1.850000000000e-06 4.518175969789e-01
+ 1.851000000000e-06 4.520615585132e-01
+ 1.852000000000e-06 4.523055200475e-01
+ 1.853000000000e-06 4.525494815817e-01
+ 1.854000000000e-06 4.527934431160e-01
+ 1.855000000000e-06 4.530374046503e-01
+ 1.856000000000e-06 4.532813661846e-01
+ 1.857000000000e-06 4.535253277189e-01
+ 1.858000000000e-06 4.537692892532e-01
+ 1.859000000000e-06 4.540132507874e-01
+ 1.860000000000e-06 4.542572123217e-01
+ 1.861000000000e-06 4.545011738560e-01
+ 1.862000000000e-06 4.547451353903e-01
+ 1.863000000000e-06 4.549890969246e-01
+ 1.864000000000e-06 4.552330584589e-01
+ 1.865000000000e-06 4.554770199931e-01
+ 1.866000000000e-06 4.557209815274e-01
+ 1.867000000000e-06 4.559649430617e-01
+ 1.868000000000e-06 4.562089045960e-01
+ 1.869000000000e-06 4.564528661303e-01
+ 1.870000000000e-06 4.566968276646e-01
+ 1.871000000000e-06 4.569407891989e-01
+ 1.872000000000e-06 4.571847507331e-01
+ 1.873000000000e-06 4.574287122674e-01
+ 1.874000000000e-06 4.576726738017e-01
+ 1.875000000000e-06 4.579166353360e-01
+ 1.876000000000e-06 4.581605968703e-01
+ 1.877000000000e-06 4.584045584046e-01
+ 1.878000000000e-06 4.586485199388e-01
+ 1.879000000000e-06 4.588924814731e-01
+ 1.880000000000e-06 4.591364430074e-01
+ 1.881000000000e-06 4.593804045417e-01
+ 1.882000000000e-06 4.596243660760e-01
+ 1.883000000000e-06 4.598683276103e-01
+ 1.884000000000e-06 4.601122891445e-01
+ 1.885000000000e-06 4.603562506788e-01
+ 1.886000000000e-06 4.606002122131e-01
+ 1.887000000000e-06 4.608441737474e-01
+ 1.888000000000e-06 4.610881352817e-01
+ 1.889000000000e-06 4.613320968160e-01
+ 1.890000000000e-06 4.615760583503e-01
+ 1.891000000000e-06 4.618200198845e-01
+ 1.892000000000e-06 4.620639814188e-01
+ 1.893000000000e-06 4.623079429531e-01
+ 1.894000000000e-06 4.625519044874e-01
+ 1.895000000000e-06 4.627958660217e-01
+ 1.896000000000e-06 4.630398275560e-01
+ 1.897000000000e-06 4.632837890902e-01
+ 1.898000000000e-06 4.635277506245e-01
+ 1.899000000000e-06 4.637717121588e-01
+ 1.900000000000e-06 4.640156736931e-01
+ 1.901000000000e-06 4.642596352274e-01
+ 1.902000000000e-06 4.645035967617e-01
+ 1.903000000000e-06 4.647475582959e-01
+ 1.904000000000e-06 4.649915198302e-01
+ 1.905000000000e-06 4.652354813645e-01
+ 1.906000000000e-06 4.654794428988e-01
+ 1.907000000000e-06 4.657234044331e-01
+ 1.908000000000e-06 4.659673659674e-01
+ 1.909000000000e-06 4.662113275017e-01
+ 1.910000000000e-06 4.664552890359e-01
+ 1.911000000000e-06 4.666992505702e-01
+ 1.912000000000e-06 4.669432121045e-01
+ 1.913000000000e-06 4.671871736388e-01
+ 1.914000000000e-06 4.674311351731e-01
+ 1.915000000000e-06 4.676750967074e-01
+ 1.916000000000e-06 4.679190582416e-01
+ 1.917000000000e-06 4.681630197759e-01
+ 1.918000000000e-06 4.684069813102e-01
+ 1.919000000000e-06 4.686509428445e-01
+ 1.920000000000e-06 4.688949043788e-01
+ 1.921000000000e-06 4.691388659131e-01
+ 1.922000000000e-06 4.693828274473e-01
+ 1.923000000000e-06 4.696267889816e-01
+ 1.924000000000e-06 4.698707505159e-01
+ 1.925000000000e-06 4.701147120502e-01
+ 1.926000000000e-06 4.703586735845e-01
+ 1.927000000000e-06 4.706026351188e-01
+ 1.928000000000e-06 4.708465966530e-01
+ 1.929000000000e-06 4.710905581873e-01
+ 1.930000000000e-06 4.713345197216e-01
+ 1.931000000000e-06 4.715784812559e-01
+ 1.932000000000e-06 4.718224427902e-01
+ 1.933000000000e-06 4.720664043245e-01
+ 1.934000000000e-06 4.723103658588e-01
+ 1.935000000000e-06 4.725543273930e-01
+ 1.936000000000e-06 4.727982889273e-01
+ 1.937000000000e-06 4.730422504616e-01
+ 1.938000000000e-06 4.732862119959e-01
+ 1.939000000000e-06 4.735301735302e-01
+ 1.940000000000e-06 4.737741350645e-01
+ 1.941000000000e-06 4.740180965987e-01
+ 1.942000000000e-06 4.742620581330e-01
+ 1.943000000000e-06 4.745060196673e-01
+ 1.944000000000e-06 4.747499812016e-01
+ 1.945000000000e-06 4.749939427359e-01
+ 1.946000000000e-06 4.752379042702e-01
+ 1.947000000000e-06 4.754818658044e-01
+ 1.948000000000e-06 4.757258273387e-01
+ 1.949000000000e-06 4.759697888730e-01
+ 1.950000000000e-06 4.762137504073e-01
+ 1.951000000000e-06 4.764577119416e-01
+ 1.952000000000e-06 4.767016734759e-01
+ 1.953000000000e-06 4.769456350102e-01
+ 1.954000000000e-06 4.771895965444e-01
+ 1.955000000000e-06 4.774335580787e-01
+ 1.956000000000e-06 4.776775196130e-01
+ 1.957000000000e-06 4.779214811473e-01
+ 1.958000000000e-06 4.781654426816e-01
+ 1.959000000000e-06 4.784094042159e-01
+ 1.960000000000e-06 4.786533657501e-01
+ 1.961000000000e-06 4.788973272844e-01
+ 1.962000000000e-06 4.791412888187e-01
+ 1.963000000000e-06 4.793852503530e-01
+ 1.964000000000e-06 4.796292118873e-01
+ 1.965000000000e-06 4.798731734216e-01
+ 1.966000000000e-06 4.801171349558e-01
+ 1.967000000000e-06 4.803610964901e-01
+ 1.968000000000e-06 4.806050580244e-01
+ 1.969000000000e-06 4.808490195587e-01
+ 1.970000000000e-06 4.810929810930e-01
+ 1.971000000000e-06 4.813369426273e-01
+ 1.972000000000e-06 4.815809041615e-01
+ 1.973000000000e-06 4.818248656958e-01
+ 1.974000000000e-06 4.820688272301e-01
+ 1.975000000000e-06 4.823127887644e-01
+ 1.976000000000e-06 4.825567502987e-01
+ 1.977000000000e-06 4.828007118330e-01
+ 1.978000000000e-06 4.830446733673e-01
+ 1.979000000000e-06 4.832886349015e-01
+ 1.980000000000e-06 4.835325964358e-01
+ 1.981000000000e-06 4.837765579701e-01
+ 1.982000000000e-06 4.840205195044e-01
+ 1.983000000000e-06 4.842644810387e-01
+ 1.984000000000e-06 4.845084425730e-01
+ 1.985000000000e-06 4.847524041072e-01
+ 1.986000000000e-06 4.849963656415e-01
+ 1.987000000000e-06 4.852403271758e-01
+ 1.988000000000e-06 4.854842887101e-01
+ 1.989000000000e-06 4.857282502444e-01
+ 1.990000000000e-06 4.859722117787e-01
+ 1.991000000000e-06 4.862161733129e-01
+ 1.992000000000e-06 4.864601348472e-01
+ 1.993000000000e-06 4.867040963815e-01
+ 1.994000000000e-06 4.869480579158e-01
+ 1.995000000000e-06 4.871920194501e-01
+ 1.996000000000e-06 4.874359809844e-01
+ 1.997000000000e-06 4.876799425187e-01
+ 1.998000000000e-06 4.879239040529e-01
+ 1.999000000000e-06 4.881678655872e-01
+ 2.000000000000e-06 4.884118271215e-01
+ 2.001000000000e-06 4.886557886558e-01
+ 2.002000000000e-06 4.888997501901e-01
+ 2.003000000000e-06 4.891437117244e-01
+ 2.004000000000e-06 4.893876732586e-01
+ 2.005000000000e-06 4.896316347929e-01
+ 2.006000000000e-06 4.898755963272e-01
+ 2.007000000000e-06 4.901195578615e-01
+ 2.008000000000e-06 4.903635193958e-01
+ 2.009000000000e-06 4.906074809301e-01
+ 2.010000000000e-06 4.908514424643e-01
+ 2.011000000000e-06 4.910954039986e-01
+ 2.012000000000e-06 4.913393655329e-01
+ 2.013000000000e-06 4.915833270672e-01
+ 2.014000000000e-06 4.918272886015e-01
+ 2.015000000000e-06 4.920712501358e-01
+ 2.016000000000e-06 4.923152116701e-01
+ 2.017000000000e-06 4.925591732043e-01
+ 2.018000000000e-06 4.928031347386e-01
+ 2.019000000000e-06 4.930470962729e-01
+ 2.020000000000e-06 4.932910578072e-01
+ 2.021000000000e-06 4.935350193415e-01
+ 2.022000000000e-06 4.937789808758e-01
+ 2.023000000000e-06 4.940229424100e-01
+ 2.024000000000e-06 4.942669039443e-01
+ 2.025000000000e-06 4.945108654786e-01
+ 2.026000000000e-06 4.947548270129e-01
+ 2.027000000000e-06 4.949987885472e-01
+ 2.028000000000e-06 4.952427500815e-01
+ 2.029000000000e-06 4.954867116157e-01
+ 2.030000000000e-06 4.957306731500e-01
+ 2.031000000000e-06 4.959746346843e-01
+ 2.032000000000e-06 4.962185962186e-01
+ 2.033000000000e-06 4.964625577529e-01
+ 2.034000000000e-06 4.967065192872e-01
+ 2.035000000000e-06 4.969504808214e-01
+ 2.036000000000e-06 4.971944423557e-01
+ 2.037000000000e-06 4.974384038900e-01
+ 2.038000000000e-06 4.976823654243e-01
+ 2.039000000000e-06 4.979263269586e-01
+ 2.040000000000e-06 4.981702884929e-01
+ 2.041000000000e-06 4.984142500272e-01
+ 2.042000000000e-06 4.986582115614e-01
+ 2.043000000000e-06 4.989021730957e-01
+ 2.044000000000e-06 4.991461346300e-01
+ 2.045000000000e-06 4.993900961643e-01
+ 2.046000000000e-06 4.996340576986e-01
+ 2.047000000000e-06 4.998780192329e-01
+ 2.048000000000e-06 5.001219807671e-01
+ 2.049000000000e-06 5.003659423014e-01
+ 2.050000000000e-06 5.006099038357e-01
+ 2.051000000000e-06 5.008538653700e-01
+ 2.052000000000e-06 5.010978269043e-01
+ 2.053000000000e-06 5.013417884386e-01
+ 2.054000000000e-06 5.015857499728e-01
+ 2.055000000000e-06 5.018297115071e-01
+ 2.056000000000e-06 5.020736730414e-01
+ 2.057000000000e-06 5.023176345757e-01
+ 2.058000000000e-06 5.025615961100e-01
+ 2.059000000000e-06 5.028055576443e-01
+ 2.060000000000e-06 5.030495191786e-01
+ 2.061000000000e-06 5.032934807128e-01
+ 2.062000000000e-06 5.035374422471e-01
+ 2.063000000000e-06 5.037814037814e-01
+ 2.064000000000e-06 5.040253653157e-01
+ 2.065000000000e-06 5.042693268500e-01
+ 2.066000000000e-06 5.045132883843e-01
+ 2.067000000000e-06 5.047572499185e-01
+ 2.068000000000e-06 5.050012114528e-01
+ 2.069000000000e-06 5.052451729871e-01
+ 2.070000000000e-06 5.054891345214e-01
+ 2.071000000000e-06 5.057330960557e-01
+ 2.072000000000e-06 5.059770575900e-01
+ 2.073000000000e-06 5.062210191242e-01
+ 2.074000000000e-06 5.064649806585e-01
+ 2.075000000000e-06 5.067089421928e-01
+ 2.076000000000e-06 5.069529037271e-01
+ 2.077000000000e-06 5.071968652614e-01
+ 2.078000000000e-06 5.074408267957e-01
+ 2.079000000000e-06 5.076847883299e-01
+ 2.080000000000e-06 5.079287498642e-01
+ 2.081000000000e-06 5.081727113985e-01
+ 2.082000000000e-06 5.084166729328e-01
+ 2.083000000000e-06 5.086606344671e-01
+ 2.084000000000e-06 5.089045960014e-01
+ 2.085000000000e-06 5.091485575357e-01
+ 2.086000000000e-06 5.093925190699e-01
+ 2.087000000000e-06 5.096364806042e-01
+ 2.088000000000e-06 5.098804421385e-01
+ 2.089000000000e-06 5.101244036728e-01
+ 2.090000000000e-06 5.103683652071e-01
+ 2.091000000000e-06 5.106123267414e-01
+ 2.092000000000e-06 5.108562882756e-01
+ 2.093000000000e-06 5.111002498099e-01
+ 2.094000000000e-06 5.113442113442e-01
+ 2.095000000000e-06 5.115881728785e-01
+ 2.096000000000e-06 5.118321344128e-01
+ 2.097000000000e-06 5.120760959471e-01
+ 2.098000000000e-06 5.123200574813e-01
+ 2.099000000000e-06 5.125640190156e-01
+ 2.100000000000e-06 5.128079805499e-01
+ 2.101000000000e-06 5.130519420842e-01
+ 2.102000000000e-06 5.132959036185e-01
+ 2.103000000000e-06 5.135398651528e-01
+ 2.104000000000e-06 5.137838266871e-01
+ 2.105000000000e-06 5.140277882213e-01
+ 2.106000000000e-06 5.142717497556e-01
+ 2.107000000000e-06 5.145157112899e-01
+ 2.108000000000e-06 5.147596728242e-01
+ 2.109000000000e-06 5.150036343585e-01
+ 2.110000000000e-06 5.152475958928e-01
+ 2.111000000000e-06 5.154915574270e-01
+ 2.112000000000e-06 5.157355189613e-01
+ 2.113000000000e-06 5.159794804956e-01
+ 2.114000000000e-06 5.162234420299e-01
+ 2.115000000000e-06 5.164674035642e-01
+ 2.116000000000e-06 5.167113650985e-01
+ 2.117000000000e-06 5.169553266327e-01
+ 2.118000000000e-06 5.171992881670e-01
+ 2.119000000000e-06 5.174432497013e-01
+ 2.120000000000e-06 5.176872112356e-01
+ 2.121000000000e-06 5.179311727699e-01
+ 2.122000000000e-06 5.181751343042e-01
+ 2.123000000000e-06 5.184190958385e-01
+ 2.124000000000e-06 5.186630573727e-01
+ 2.125000000000e-06 5.189070189070e-01
+ 2.126000000000e-06 5.191509804413e-01
+ 2.127000000000e-06 5.193949419756e-01
+ 2.128000000000e-06 5.196389035099e-01
+ 2.129000000000e-06 5.198828650442e-01
+ 2.130000000000e-06 5.201268265784e-01
+ 2.131000000000e-06 5.203707881127e-01
+ 2.132000000000e-06 5.206147496470e-01
+ 2.133000000000e-06 5.208587111813e-01
+ 2.134000000000e-06 5.211026727156e-01
+ 2.135000000000e-06 5.213466342499e-01
+ 2.136000000000e-06 5.215905957841e-01
+ 2.137000000000e-06 5.218345573184e-01
+ 2.138000000000e-06 5.220785188527e-01
+ 2.139000000000e-06 5.223224803870e-01
+ 2.140000000000e-06 5.225664419213e-01
+ 2.141000000000e-06 5.228104034556e-01
+ 2.142000000000e-06 5.230543649898e-01
+ 2.143000000000e-06 5.232983265241e-01
+ 2.144000000000e-06 5.235422880584e-01
+ 2.145000000000e-06 5.237862495927e-01
+ 2.146000000000e-06 5.240302111270e-01
+ 2.147000000000e-06 5.242741726613e-01
+ 2.148000000000e-06 5.245181341956e-01
+ 2.149000000000e-06 5.247620957298e-01
+ 2.150000000000e-06 5.250060572641e-01
+ 2.151000000000e-06 5.252500187984e-01
+ 2.152000000000e-06 5.254939803327e-01
+ 2.153000000000e-06 5.257379418670e-01
+ 2.154000000000e-06 5.259819034013e-01
+ 2.155000000000e-06 5.262258649355e-01
+ 2.156000000000e-06 5.264698264698e-01
+ 2.157000000000e-06 5.267137880041e-01
+ 2.158000000000e-06 5.269577495384e-01
+ 2.159000000000e-06 5.272017110727e-01
+ 2.160000000000e-06 5.274456726070e-01
+ 2.161000000000e-06 5.276896341412e-01
+ 2.162000000000e-06 5.279335956755e-01
+ 2.163000000000e-06 5.281775572098e-01
+ 2.164000000000e-06 5.284215187441e-01
+ 2.165000000000e-06 5.286654802784e-01
+ 2.166000000000e-06 5.289094418127e-01
+ 2.167000000000e-06 5.291534033470e-01
+ 2.168000000000e-06 5.293973648812e-01
+ 2.169000000000e-06 5.296413264155e-01
+ 2.170000000000e-06 5.298852879498e-01
+ 2.171000000000e-06 5.301292494841e-01
+ 2.172000000000e-06 5.303732110184e-01
+ 2.173000000000e-06 5.306171725527e-01
+ 2.174000000000e-06 5.308611340869e-01
+ 2.175000000000e-06 5.311050956212e-01
+ 2.176000000000e-06 5.313490571555e-01
+ 2.177000000000e-06 5.315930186898e-01
+ 2.178000000000e-06 5.318369802241e-01
+ 2.179000000000e-06 5.320809417584e-01
+ 2.180000000000e-06 5.323249032926e-01
+ 2.181000000000e-06 5.325688648269e-01
+ 2.182000000000e-06 5.328128263612e-01
+ 2.183000000000e-06 5.330567878955e-01
+ 2.184000000000e-06 5.333007494298e-01
+ 2.185000000000e-06 5.335447109641e-01
+ 2.186000000000e-06 5.337886724983e-01
+ 2.187000000000e-06 5.340326340326e-01
+ 2.188000000000e-06 5.342765955669e-01
+ 2.189000000000e-06 5.345205571012e-01
+ 2.190000000000e-06 5.347645186355e-01
+ 2.191000000000e-06 5.350084801698e-01
+ 2.192000000000e-06 5.352524417041e-01
+ 2.193000000000e-06 5.354964032383e-01
+ 2.194000000000e-06 5.357403647726e-01
+ 2.195000000000e-06 5.359843263069e-01
+ 2.196000000000e-06 5.362282878412e-01
+ 2.197000000000e-06 5.364722493755e-01
+ 2.198000000000e-06 5.367162109098e-01
+ 2.199000000000e-06 5.369601724440e-01
+ 2.200000000000e-06 5.372041339783e-01
+ 2.201000000000e-06 5.374480955126e-01
+ 2.202000000000e-06 5.376920570469e-01
+ 2.203000000000e-06 5.379360185812e-01
+ 2.204000000000e-06 5.381799801155e-01
+ 2.205000000000e-06 5.384239416497e-01
+ 2.206000000000e-06 5.386679031840e-01
+ 2.207000000000e-06 5.389118647183e-01
+ 2.208000000000e-06 5.391558262526e-01
+ 2.209000000000e-06 5.393997877869e-01
+ 2.210000000000e-06 5.396437493212e-01
+ 2.211000000000e-06 5.398877108555e-01
+ 2.212000000000e-06 5.401316723897e-01
+ 2.213000000000e-06 5.403756339240e-01
+ 2.214000000000e-06 5.406195954583e-01
+ 2.215000000000e-06 5.408635569926e-01
+ 2.216000000000e-06 5.411075185269e-01
+ 2.217000000000e-06 5.413514800612e-01
+ 2.218000000000e-06 5.415954415954e-01
+ 2.219000000000e-06 5.418394031297e-01
+ 2.220000000000e-06 5.420833646640e-01
+ 2.221000000000e-06 5.423273261983e-01
+ 2.222000000000e-06 5.425712877326e-01
+ 2.223000000000e-06 5.428152492669e-01
+ 2.224000000000e-06 5.430592108011e-01
+ 2.225000000000e-06 5.433031723354e-01
+ 2.226000000000e-06 5.435471338697e-01
+ 2.227000000000e-06 5.437910954040e-01
+ 2.228000000000e-06 5.440350569383e-01
+ 2.229000000000e-06 5.442790184726e-01
+ 2.230000000000e-06 5.445229800069e-01
+ 2.231000000000e-06 5.447669415411e-01
+ 2.232000000000e-06 5.450109030754e-01
+ 2.233000000000e-06 5.452548646097e-01
+ 2.234000000000e-06 5.454988261440e-01
+ 2.235000000000e-06 5.457427876783e-01
+ 2.236000000000e-06 5.459867492126e-01
+ 2.237000000000e-06 5.462307107468e-01
+ 2.238000000000e-06 5.464746722811e-01
+ 2.239000000000e-06 5.467186338154e-01
+ 2.240000000000e-06 5.469625953497e-01
+ 2.241000000000e-06 5.472065568840e-01
+ 2.242000000000e-06 5.474505184183e-01
+ 2.243000000000e-06 5.476944799525e-01
+ 2.244000000000e-06 5.479384414868e-01
+ 2.245000000000e-06 5.481824030211e-01
+ 2.246000000000e-06 5.484263645554e-01
+ 2.247000000000e-06 5.486703260897e-01
+ 2.248000000000e-06 5.489142876240e-01
+ 2.249000000000e-06 5.491582491582e-01
+ 2.250000000000e-06 5.494022106925e-01
+ 2.251000000000e-06 5.496461722268e-01
+ 2.252000000000e-06 5.498901337611e-01
+ 2.253000000000e-06 5.501340952954e-01
+ 2.254000000000e-06 5.503780568297e-01
+ 2.255000000000e-06 5.506220183640e-01
+ 2.256000000000e-06 5.508659798982e-01
+ 2.257000000000e-06 5.511099414325e-01
+ 2.258000000000e-06 5.513539029668e-01
+ 2.259000000000e-06 5.515978645011e-01
+ 2.260000000000e-06 5.518418260354e-01
+ 2.261000000000e-06 5.520857875697e-01
+ 2.262000000000e-06 5.523297491039e-01
+ 2.263000000000e-06 5.525737106382e-01
+ 2.264000000000e-06 5.528176721725e-01
+ 2.265000000000e-06 5.530616337068e-01
+ 2.266000000000e-06 5.533055952411e-01
+ 2.267000000000e-06 5.535495567754e-01
+ 2.268000000000e-06 5.537935183096e-01
+ 2.269000000000e-06 5.540374798439e-01
+ 2.270000000000e-06 5.542814413782e-01
+ 2.271000000000e-06 5.545254029125e-01
+ 2.272000000000e-06 5.547693644468e-01
+ 2.273000000000e-06 5.550133259811e-01
+ 2.274000000000e-06 5.552572875154e-01
+ 2.275000000000e-06 5.555012490496e-01
+ 2.276000000000e-06 5.557452105839e-01
+ 2.277000000000e-06 5.559891721182e-01
+ 2.278000000000e-06 5.562331336525e-01
+ 2.279000000000e-06 5.564770951868e-01
+ 2.280000000000e-06 5.567210567211e-01
+ 2.281000000000e-06 5.569650182553e-01
+ 2.282000000000e-06 5.572089797896e-01
+ 2.283000000000e-06 5.574529413239e-01
+ 2.284000000000e-06 5.576969028582e-01
+ 2.285000000000e-06 5.579408643925e-01
+ 2.286000000000e-06 5.581848259268e-01
+ 2.287000000000e-06 5.584287874610e-01
+ 2.288000000000e-06 5.586727489953e-01
+ 2.289000000000e-06 5.589167105296e-01
+ 2.290000000000e-06 5.591606720639e-01
+ 2.291000000000e-06 5.594046335982e-01
+ 2.292000000000e-06 5.596485951325e-01
+ 2.293000000000e-06 5.598925566668e-01
+ 2.294000000000e-06 5.601365182010e-01
+ 2.295000000000e-06 5.603804797353e-01
+ 2.296000000000e-06 5.606244412696e-01
+ 2.297000000000e-06 5.608684028039e-01
+ 2.298000000000e-06 5.611123643382e-01
+ 2.299000000000e-06 5.613563258725e-01
+ 2.300000000000e-06 5.616002874067e-01
+ 2.301000000000e-06 5.618442489410e-01
+ 2.302000000000e-06 5.620882104753e-01
+ 2.303000000000e-06 5.623321720096e-01
+ 2.304000000000e-06 5.625761335439e-01
+ 2.305000000000e-06 5.628200950782e-01
+ 2.306000000000e-06 5.630640566124e-01
+ 2.307000000000e-06 5.633080181467e-01
+ 2.308000000000e-06 5.635519796810e-01
+ 2.309000000000e-06 5.637959412153e-01
+ 2.310000000000e-06 5.640399027496e-01
+ 2.311000000000e-06 5.642838642839e-01
+ 2.312000000000e-06 5.645278258181e-01
+ 2.313000000000e-06 5.647717873524e-01
+ 2.314000000000e-06 5.650157488867e-01
+ 2.315000000000e-06 5.652597104210e-01
+ 2.316000000000e-06 5.655036719553e-01
+ 2.317000000000e-06 5.657476334896e-01
+ 2.318000000000e-06 5.659915950239e-01
+ 2.319000000000e-06 5.662355565581e-01
+ 2.320000000000e-06 5.664795180924e-01
+ 2.321000000000e-06 5.667234796267e-01
+ 2.322000000000e-06 5.669674411610e-01
+ 2.323000000000e-06 5.672114026953e-01
+ 2.324000000000e-06 5.674553642296e-01
+ 2.325000000000e-06 5.676993257638e-01
+ 2.326000000000e-06 5.679432872981e-01
+ 2.327000000000e-06 5.681872488324e-01
+ 2.328000000000e-06 5.684312103667e-01
+ 2.329000000000e-06 5.686751719010e-01
+ 2.330000000000e-06 5.689191334353e-01
+ 2.331000000000e-06 5.691630949695e-01
+ 2.332000000000e-06 5.694070565038e-01
+ 2.333000000000e-06 5.696510180381e-01
+ 2.334000000000e-06 5.698949795724e-01
+ 2.335000000000e-06 5.701389411067e-01
+ 2.336000000000e-06 5.703829026410e-01
+ 2.337000000000e-06 5.706268641753e-01
+ 2.338000000000e-06 5.708708257095e-01
+ 2.339000000000e-06 5.711147872438e-01
+ 2.340000000000e-06 5.713587487781e-01
+ 2.341000000000e-06 5.716027103124e-01
+ 2.342000000000e-06 5.718466718467e-01
+ 2.343000000000e-06 5.720906333810e-01
+ 2.344000000000e-06 5.723345949152e-01
+ 2.345000000000e-06 5.725785564495e-01
+ 2.346000000000e-06 5.728225179838e-01
+ 2.347000000000e-06 5.730664795181e-01
+ 2.348000000000e-06 5.733104410524e-01
+ 2.349000000000e-06 5.735544025867e-01
+ 2.350000000000e-06 5.737983641209e-01
+ 2.351000000000e-06 5.740423256552e-01
+ 2.352000000000e-06 5.742862871895e-01
+ 2.353000000000e-06 5.745302487238e-01
+ 2.354000000000e-06 5.747742102581e-01
+ 2.355000000000e-06 5.750181717924e-01
+ 2.356000000000e-06 5.752621333266e-01
+ 2.357000000000e-06 5.755060948609e-01
+ 2.358000000000e-06 5.757500563952e-01
+ 2.359000000000e-06 5.759940179295e-01
+ 2.360000000000e-06 5.762379794638e-01
+ 2.361000000000e-06 5.764819409981e-01
+ 2.362000000000e-06 5.767259025324e-01
+ 2.363000000000e-06 5.769698640666e-01
+ 2.364000000000e-06 5.772138256009e-01
+ 2.365000000000e-06 5.774577871352e-01
+ 2.366000000000e-06 5.777017486695e-01
+ 2.367000000000e-06 5.779457102038e-01
+ 2.368000000000e-06 5.781896717381e-01
+ 2.369000000000e-06 5.784336332723e-01
+ 2.370000000000e-06 5.786775948066e-01
+ 2.371000000000e-06 5.789215563409e-01
+ 2.372000000000e-06 5.791655178752e-01
+ 2.373000000000e-06 5.794094794095e-01
+ 2.374000000000e-06 5.796534409438e-01
+ 2.375000000000e-06 5.798974024780e-01
+ 2.376000000000e-06 5.801413640123e-01
+ 2.377000000000e-06 5.803853255466e-01
+ 2.378000000000e-06 5.806292870809e-01
+ 2.379000000000e-06 5.808732486152e-01
+ 2.380000000000e-06 5.811172101495e-01
+ 2.381000000000e-06 5.813611716838e-01
+ 2.382000000000e-06 5.816051332180e-01
+ 2.383000000000e-06 5.818490947523e-01
+ 2.384000000000e-06 5.820930562866e-01
+ 2.385000000000e-06 5.823370178209e-01
+ 2.386000000000e-06 5.825809793552e-01
+ 2.387000000000e-06 5.828249408895e-01
+ 2.388000000000e-06 5.830689024237e-01
+ 2.389000000000e-06 5.833128639580e-01
+ 2.390000000000e-06 5.835568254923e-01
+ 2.391000000000e-06 5.838007870266e-01
+ 2.392000000000e-06 5.840447485609e-01
+ 2.393000000000e-06 5.842887100952e-01
+ 2.394000000000e-06 5.845326716294e-01
+ 2.395000000000e-06 5.847766331637e-01
+ 2.396000000000e-06 5.850205946980e-01
+ 2.397000000000e-06 5.852645562323e-01
+ 2.398000000000e-06 5.855085177666e-01
+ 2.399000000000e-06 5.857524793009e-01
+ 2.400000000000e-06 5.859964408352e-01
+ 2.401000000000e-06 5.862404023694e-01
+ 2.402000000000e-06 5.864843639037e-01
+ 2.403000000000e-06 5.867283254380e-01
+ 2.404000000000e-06 5.869722869723e-01
+ 2.405000000000e-06 5.872162485066e-01
+ 2.406000000000e-06 5.874602100409e-01
+ 2.407000000000e-06 5.877041715751e-01
+ 2.408000000000e-06 5.879481331094e-01
+ 2.409000000000e-06 5.881920946437e-01
+ 2.410000000000e-06 5.884360561780e-01
+ 2.411000000000e-06 5.886800177123e-01
+ 2.412000000000e-06 5.889239792466e-01
+ 2.413000000000e-06 5.891679407808e-01
+ 2.414000000000e-06 5.894119023151e-01
+ 2.415000000000e-06 5.896558638494e-01
+ 2.416000000000e-06 5.898998253837e-01
+ 2.417000000000e-06 5.901437869180e-01
+ 2.418000000000e-06 5.903877484523e-01
+ 2.419000000000e-06 5.906317099865e-01
+ 2.420000000000e-06 5.908756715208e-01
+ 2.421000000000e-06 5.911196330551e-01
+ 2.422000000000e-06 5.913635945894e-01
+ 2.423000000000e-06 5.916075561237e-01
+ 2.424000000000e-06 5.918515176580e-01
+ 2.425000000000e-06 5.920954791923e-01
+ 2.426000000000e-06 5.923394407265e-01
+ 2.427000000000e-06 5.925834022608e-01
+ 2.428000000000e-06 5.928273637951e-01
+ 2.429000000000e-06 5.930713253294e-01
+ 2.430000000000e-06 5.933152868637e-01
+ 2.431000000000e-06 5.935592483980e-01
+ 2.432000000000e-06 5.938032099322e-01
+ 2.433000000000e-06 5.940471714665e-01
+ 2.434000000000e-06 5.942911330008e-01
+ 2.435000000000e-06 5.945350945351e-01
+ 2.436000000000e-06 5.947790560694e-01
+ 2.437000000000e-06 5.950230176037e-01
+ 2.438000000000e-06 5.952669791379e-01
+ 2.439000000000e-06 5.955109406722e-01
+ 2.440000000000e-06 5.957549022065e-01
+ 2.441000000000e-06 5.959988637408e-01
+ 2.442000000000e-06 5.962428252751e-01
+ 2.443000000000e-06 5.964867868094e-01
+ 2.444000000000e-06 5.967307483437e-01
+ 2.445000000000e-06 5.969747098779e-01
+ 2.446000000000e-06 5.972186714122e-01
+ 2.447000000000e-06 5.974626329465e-01
+ 2.448000000000e-06 5.977065944808e-01
+ 2.449000000000e-06 5.979505560151e-01
+ 2.450000000000e-06 5.981945175494e-01
+ 2.451000000000e-06 5.984384790836e-01
+ 2.452000000000e-06 5.986824406179e-01
+ 2.453000000000e-06 5.989264021522e-01
+ 2.454000000000e-06 5.991703636865e-01
+ 2.455000000000e-06 5.994143252208e-01
+ 2.456000000000e-06 5.996582867551e-01
+ 2.457000000000e-06 5.999022482893e-01
+ 2.458000000000e-06 6.001462098236e-01
+ 2.459000000000e-06 6.003901713579e-01
+ 2.460000000000e-06 6.006341328922e-01
+ 2.461000000000e-06 6.008780944265e-01
+ 2.462000000000e-06 6.011220559608e-01
+ 2.463000000000e-06 6.013660174950e-01
+ 2.464000000000e-06 6.016099790293e-01
+ 2.465000000000e-06 6.018539405636e-01
+ 2.466000000000e-06 6.020979020979e-01
+ 2.467000000000e-06 6.023418636322e-01
+ 2.468000000000e-06 6.025858251665e-01
+ 2.469000000000e-06 6.028297867008e-01
+ 2.470000000000e-06 6.030737482350e-01
+ 2.471000000000e-06 6.033177097693e-01
+ 2.472000000000e-06 6.035616713036e-01
+ 2.473000000000e-06 6.038056328379e-01
+ 2.474000000000e-06 6.040495943722e-01
+ 2.475000000000e-06 6.042935559065e-01
+ 2.476000000000e-06 6.045375174407e-01
+ 2.477000000000e-06 6.047814789750e-01
+ 2.478000000000e-06 6.050254405093e-01
+ 2.479000000000e-06 6.052694020436e-01
+ 2.480000000000e-06 6.055133635779e-01
+ 2.481000000000e-06 6.057573251122e-01
+ 2.482000000000e-06 6.060012866464e-01
+ 2.483000000000e-06 6.062452481807e-01
+ 2.484000000000e-06 6.064892097150e-01
+ 2.485000000000e-06 6.067331712493e-01
+ 2.486000000000e-06 6.069771327836e-01
+ 2.487000000000e-06 6.072210943179e-01
+ 2.488000000000e-06 6.074650558522e-01
+ 2.489000000000e-06 6.077090173864e-01
+ 2.490000000000e-06 6.079529789207e-01
+ 2.491000000000e-06 6.081969404550e-01
+ 2.492000000000e-06 6.084409019893e-01
+ 2.493000000000e-06 6.086848635236e-01
+ 2.494000000000e-06 6.089288250579e-01
+ 2.495000000000e-06 6.091727865921e-01
+ 2.496000000000e-06 6.094167481264e-01
+ 2.497000000000e-06 6.096607096607e-01
+ 2.498000000000e-06 6.099046711950e-01
+ 2.499000000000e-06 6.101486327293e-01
+ 2.500000000000e-06 6.103925942636e-01
+ 2.501000000000e-06 6.106365557978e-01
+ 2.502000000000e-06 6.108805173321e-01
+ 2.503000000000e-06 6.111244788664e-01
+ 2.504000000000e-06 6.113684404007e-01
+ 2.505000000000e-06 6.116124019350e-01
+ 2.506000000000e-06 6.118563634693e-01
+ 2.507000000000e-06 6.121003250036e-01
+ 2.508000000000e-06 6.123442865378e-01
+ 2.509000000000e-06 6.125882480721e-01
+ 2.510000000000e-06 6.128322096064e-01
+ 2.511000000000e-06 6.130761711407e-01
+ 2.512000000000e-06 6.133201326750e-01
+ 2.513000000000e-06 6.135640942093e-01
+ 2.514000000000e-06 6.138080557435e-01
+ 2.515000000000e-06 6.140520172778e-01
+ 2.516000000000e-06 6.142959788121e-01
+ 2.517000000000e-06 6.145399403464e-01
+ 2.518000000000e-06 6.147839018807e-01
+ 2.519000000000e-06 6.150278634150e-01
+ 2.520000000000e-06 6.152718249492e-01
+ 2.521000000000e-06 6.155157864835e-01
+ 2.522000000000e-06 6.157597480178e-01
+ 2.523000000000e-06 6.160037095521e-01
+ 2.524000000000e-06 6.162476710864e-01
+ 2.525000000000e-06 6.164916326207e-01
+ 2.526000000000e-06 6.167355941549e-01
+ 2.527000000000e-06 6.169795556892e-01
+ 2.528000000000e-06 6.172235172235e-01
+ 2.529000000000e-06 6.174674787578e-01
+ 2.530000000000e-06 6.177114402921e-01
+ 2.531000000000e-06 6.179554018264e-01
+ 2.532000000000e-06 6.181993633607e-01
+ 2.533000000000e-06 6.184433248949e-01
+ 2.534000000000e-06 6.186872864292e-01
+ 2.535000000000e-06 6.189312479635e-01
+ 2.536000000000e-06 6.191752094978e-01
+ 2.537000000000e-06 6.194191710321e-01
+ 2.538000000000e-06 6.196631325664e-01
+ 2.539000000000e-06 6.199070941006e-01
+ 2.540000000000e-06 6.201510556349e-01
+ 2.541000000000e-06 6.203950171692e-01
+ 2.542000000000e-06 6.206389787035e-01
+ 2.543000000000e-06 6.208829402378e-01
+ 2.544000000000e-06 6.211269017721e-01
+ 2.545000000000e-06 6.213708633063e-01
+ 2.546000000000e-06 6.216148248406e-01
+ 2.547000000000e-06 6.218587863749e-01
+ 2.548000000000e-06 6.221027479092e-01
+ 2.549000000000e-06 6.223467094435e-01
+ 2.550000000000e-06 6.225906709778e-01
+ 2.551000000000e-06 6.228346325121e-01
+ 2.552000000000e-06 6.230785940463e-01
+ 2.553000000000e-06 6.233225555806e-01
+ 2.554000000000e-06 6.235665171149e-01
+ 2.555000000000e-06 6.238104786492e-01
+ 2.556000000000e-06 6.240544401835e-01
+ 2.557000000000e-06 6.242984017178e-01
+ 2.558000000000e-06 6.245423632520e-01
+ 2.559000000000e-06 6.247863247863e-01
+ 2.560000000000e-06 6.250302863206e-01
+ 2.561000000000e-06 6.252742478549e-01
+ 2.562000000000e-06 6.255182093892e-01
+ 2.563000000000e-06 6.257621709235e-01
+ 2.564000000000e-06 6.260061324577e-01
+ 2.565000000000e-06 6.262500939920e-01
+ 2.566000000000e-06 6.264940555263e-01
+ 2.567000000000e-06 6.267380170606e-01
+ 2.568000000000e-06 6.269819785949e-01
+ 2.569000000000e-06 6.272259401292e-01
+ 2.570000000000e-06 6.274699016635e-01
+ 2.571000000000e-06 6.277138631977e-01
+ 2.572000000000e-06 6.279578247320e-01
+ 2.573000000000e-06 6.282017862663e-01
+ 2.574000000000e-06 6.284457478006e-01
+ 2.575000000000e-06 6.286897093349e-01
+ 2.576000000000e-06 6.289336708692e-01
+ 2.577000000000e-06 6.291776324034e-01
+ 2.578000000000e-06 6.294215939377e-01
+ 2.579000000000e-06 6.296655554720e-01
+ 2.580000000000e-06 6.299095170063e-01
+ 2.581000000000e-06 6.301534785406e-01
+ 2.582000000000e-06 6.303974400749e-01
+ 2.583000000000e-06 6.306414016091e-01
+ 2.584000000000e-06 6.308853631434e-01
+ 2.585000000000e-06 6.311293246777e-01
+ 2.586000000000e-06 6.313732862120e-01
+ 2.587000000000e-06 6.316172477463e-01
+ 2.588000000000e-06 6.318612092806e-01
+ 2.589000000000e-06 6.321051708148e-01
+ 2.590000000000e-06 6.323491323491e-01
+ 2.591000000000e-06 6.325930938834e-01
+ 2.592000000000e-06 6.328370554177e-01
+ 2.593000000000e-06 6.330810169520e-01
+ 2.594000000000e-06 6.333249784863e-01
+ 2.595000000000e-06 6.335689400206e-01
+ 2.596000000000e-06 6.338129015548e-01
+ 2.597000000000e-06 6.340568630891e-01
+ 2.598000000000e-06 6.343008246234e-01
+ 2.599000000000e-06 6.345447861577e-01
+ 2.600000000000e-06 6.347887476920e-01
+ 2.601000000000e-06 6.350327092263e-01
+ 2.602000000000e-06 6.352766707605e-01
+ 2.603000000000e-06 6.355206322948e-01
+ 2.604000000000e-06 6.357645938291e-01
+ 2.605000000000e-06 6.360085553634e-01
+ 2.606000000000e-06 6.362525168977e-01
+ 2.607000000000e-06 6.364964784320e-01
+ 2.608000000000e-06 6.367404399662e-01
+ 2.609000000000e-06 6.369844015005e-01
+ 2.610000000000e-06 6.372283630348e-01
+ 2.611000000000e-06 6.374723245691e-01
+ 2.612000000000e-06 6.377162861034e-01
+ 2.613000000000e-06 6.379602476377e-01
+ 2.614000000000e-06 6.382042091720e-01
+ 2.615000000000e-06 6.384481707062e-01
+ 2.616000000000e-06 6.386921322405e-01
+ 2.617000000000e-06 6.389360937748e-01
+ 2.618000000000e-06 6.391800553091e-01
+ 2.619000000000e-06 6.394240168434e-01
+ 2.620000000000e-06 6.396679783777e-01
+ 2.621000000000e-06 6.399119399119e-01
+ 2.622000000000e-06 6.401559014462e-01
+ 2.623000000000e-06 6.403998629805e-01
+ 2.624000000000e-06 6.406438245148e-01
+ 2.625000000000e-06 6.408877860491e-01
+ 2.626000000000e-06 6.411317475834e-01
+ 2.627000000000e-06 6.413757091176e-01
+ 2.628000000000e-06 6.416196706519e-01
+ 2.629000000000e-06 6.418636321862e-01
+ 2.630000000000e-06 6.421075937205e-01
+ 2.631000000000e-06 6.423515552548e-01
+ 2.632000000000e-06 6.425955167891e-01
+ 2.633000000000e-06 6.428394783233e-01
+ 2.634000000000e-06 6.430834398576e-01
+ 2.635000000000e-06 6.433274013919e-01
+ 2.636000000000e-06 6.435713629262e-01
+ 2.637000000000e-06 6.438153244605e-01
+ 2.638000000000e-06 6.440592859948e-01
+ 2.639000000000e-06 6.443032475291e-01
+ 2.640000000000e-06 6.445472090633e-01
+ 2.641000000000e-06 6.447911705976e-01
+ 2.642000000000e-06 6.450351321319e-01
+ 2.643000000000e-06 6.452790936662e-01
+ 2.644000000000e-06 6.455230552005e-01
+ 2.645000000000e-06 6.457670167348e-01
+ 2.646000000000e-06 6.460109782690e-01
+ 2.647000000000e-06 6.462549398033e-01
+ 2.648000000000e-06 6.464989013376e-01
+ 2.649000000000e-06 6.467428628719e-01
+ 2.650000000000e-06 6.469868244062e-01
+ 2.651000000000e-06 6.472307859405e-01
+ 2.652000000000e-06 6.474747474747e-01
+ 2.653000000000e-06 6.477187090090e-01
+ 2.654000000000e-06 6.479626705433e-01
+ 2.655000000000e-06 6.482066320776e-01
+ 2.656000000000e-06 6.484505936119e-01
+ 2.657000000000e-06 6.486945551462e-01
+ 2.658000000000e-06 6.489385166805e-01
+ 2.659000000000e-06 6.491824782147e-01
+ 2.660000000000e-06 6.494264397490e-01
+ 2.661000000000e-06 6.496704012833e-01
+ 2.662000000000e-06 6.499143628176e-01
+ 2.663000000000e-06 6.501583243519e-01
+ 2.664000000000e-06 6.504022858862e-01
+ 2.665000000000e-06 6.506462474204e-01
+ 2.666000000000e-06 6.508902089547e-01
+ 2.667000000000e-06 6.511341704890e-01
+ 2.668000000000e-06 6.513781320233e-01
+ 2.669000000000e-06 6.516220935576e-01
+ 2.670000000000e-06 6.518660550919e-01
+ 2.671000000000e-06 6.521100166261e-01
+ 2.672000000000e-06 6.523539781604e-01
+ 2.673000000000e-06 6.525979396947e-01
+ 2.674000000000e-06 6.528419012290e-01
+ 2.675000000000e-06 6.530858627633e-01
+ 2.676000000000e-06 6.533298242976e-01
+ 2.677000000000e-06 6.535737858319e-01
+ 2.678000000000e-06 6.538177473661e-01
+ 2.679000000000e-06 6.540617089004e-01
+ 2.680000000000e-06 6.543056704347e-01
+ 2.681000000000e-06 6.545496319690e-01
+ 2.682000000000e-06 6.547935935033e-01
+ 2.683000000000e-06 6.550375550376e-01
+ 2.684000000000e-06 6.552815165718e-01
+ 2.685000000000e-06 6.555254781061e-01
+ 2.686000000000e-06 6.557694396404e-01
+ 2.687000000000e-06 6.560134011747e-01
+ 2.688000000000e-06 6.562573627090e-01
+ 2.689000000000e-06 6.565013242433e-01
+ 2.690000000000e-06 6.567452857775e-01
+ 2.691000000000e-06 6.569892473118e-01
+ 2.692000000000e-06 6.572332088461e-01
+ 2.693000000000e-06 6.574771703804e-01
+ 2.694000000000e-06 6.577211319147e-01
+ 2.695000000000e-06 6.579650934490e-01
+ 2.696000000000e-06 6.582090549832e-01
+ 2.697000000000e-06 6.584530165175e-01
+ 2.698000000000e-06 6.586969780518e-01
+ 2.699000000000e-06 6.589409395861e-01
+ 2.700000000000e-06 6.591849011204e-01
+ 2.701000000000e-06 6.594288626547e-01
+ 2.702000000000e-06 6.596728241890e-01
+ 2.703000000000e-06 6.599167857232e-01
+ 2.704000000000e-06 6.601607472575e-01
+ 2.705000000000e-06 6.604047087918e-01
+ 2.706000000000e-06 6.606486703261e-01
+ 2.707000000000e-06 6.608926318604e-01
+ 2.708000000000e-06 6.611365933947e-01
+ 2.709000000000e-06 6.613805549289e-01
+ 2.710000000000e-06 6.616245164632e-01
+ 2.711000000000e-06 6.618684779975e-01
+ 2.712000000000e-06 6.621124395318e-01
+ 2.713000000000e-06 6.623564010661e-01
+ 2.714000000000e-06 6.626003626004e-01
+ 2.715000000000e-06 6.628443241346e-01
+ 2.716000000000e-06 6.630882856689e-01
+ 2.717000000000e-06 6.633322472032e-01
+ 2.718000000000e-06 6.635762087375e-01
+ 2.719000000000e-06 6.638201702718e-01
+ 2.720000000000e-06 6.640641318061e-01
+ 2.721000000000e-06 6.643080933404e-01
+ 2.722000000000e-06 6.645520548746e-01
+ 2.723000000000e-06 6.647960164089e-01
+ 2.724000000000e-06 6.650399779432e-01
+ 2.725000000000e-06 6.652839394775e-01
+ 2.726000000000e-06 6.655279010118e-01
+ 2.727000000000e-06 6.657718625461e-01
+ 2.728000000000e-06 6.660158240803e-01
+ 2.729000000000e-06 6.662597856146e-01
+ 2.730000000000e-06 6.665037471489e-01
+ 2.731000000000e-06 6.667477086832e-01
+ 2.732000000000e-06 6.669916702175e-01
+ 2.733000000000e-06 6.672356317518e-01
+ 2.734000000000e-06 6.674795932860e-01
+ 2.735000000000e-06 6.677235548203e-01
+ 2.736000000000e-06 6.679675163546e-01
+ 2.737000000000e-06 6.682114778889e-01
+ 2.738000000000e-06 6.684554394232e-01
+ 2.739000000000e-06 6.686994009575e-01
+ 2.740000000000e-06 6.689433624917e-01
+ 2.741000000000e-06 6.691873240260e-01
+ 2.742000000000e-06 6.694312855603e-01
+ 2.743000000000e-06 6.696752470946e-01
+ 2.744000000000e-06 6.699192086289e-01
+ 2.745000000000e-06 6.701631701632e-01
+ 2.746000000000e-06 6.704071316975e-01
+ 2.747000000000e-06 6.706510932317e-01
+ 2.748000000000e-06 6.708950547660e-01
+ 2.749000000000e-06 6.711390163003e-01
+ 2.750000000000e-06 6.713829778346e-01
+ 2.751000000000e-06 6.716269393689e-01
+ 2.752000000000e-06 6.718709009032e-01
+ 2.753000000000e-06 6.721148624374e-01
+ 2.754000000000e-06 6.723588239717e-01
+ 2.755000000000e-06 6.726027855060e-01
+ 2.756000000000e-06 6.728467470403e-01
+ 2.757000000000e-06 6.730907085746e-01
+ 2.758000000000e-06 6.733346701089e-01
+ 2.759000000000e-06 6.735786316431e-01
+ 2.760000000000e-06 6.738225931774e-01
+ 2.761000000000e-06 6.740665547117e-01
+ 2.762000000000e-06 6.743105162460e-01
+ 2.763000000000e-06 6.745544777803e-01
+ 2.764000000000e-06 6.747984393146e-01
+ 2.765000000000e-06 6.750424008489e-01
+ 2.766000000000e-06 6.752863623831e-01
+ 2.767000000000e-06 6.755303239174e-01
+ 2.768000000000e-06 6.757742854517e-01
+ 2.769000000000e-06 6.760182469860e-01
+ 2.770000000000e-06 6.762622085203e-01
+ 2.771000000000e-06 6.765061700546e-01
+ 2.772000000000e-06 6.767501315888e-01
+ 2.773000000000e-06 6.769940931231e-01
+ 2.774000000000e-06 6.772380546574e-01
+ 2.775000000000e-06 6.774820161917e-01
+ 2.776000000000e-06 6.777259777260e-01
+ 2.777000000000e-06 6.779699392603e-01
+ 2.778000000000e-06 6.782139007945e-01
+ 2.779000000000e-06 6.784578623288e-01
+ 2.780000000000e-06 6.787018238631e-01
+ 2.781000000000e-06 6.789457853974e-01
+ 2.782000000000e-06 6.791897469317e-01
+ 2.783000000000e-06 6.794337084660e-01
+ 2.784000000000e-06 6.796776700003e-01
+ 2.785000000000e-06 6.799216315345e-01
+ 2.786000000000e-06 6.801655930688e-01
+ 2.787000000000e-06 6.804095546031e-01
+ 2.788000000000e-06 6.806535161374e-01
+ 2.789000000000e-06 6.808974776717e-01
+ 2.790000000000e-06 6.811414392060e-01
+ 2.791000000000e-06 6.813854007402e-01
+ 2.792000000000e-06 6.816293622745e-01
+ 2.793000000000e-06 6.818733238088e-01
+ 2.794000000000e-06 6.821172853431e-01
+ 2.795000000000e-06 6.823612468774e-01
+ 2.796000000000e-06 6.826052084117e-01
+ 2.797000000000e-06 6.828491699459e-01
+ 2.798000000000e-06 6.830931314802e-01
+ 2.799000000000e-06 6.833370930145e-01
+ 2.800000000000e-06 6.835810545488e-01
+ 2.801000000000e-06 6.838250160831e-01
+ 2.802000000000e-06 6.840689776174e-01
+ 2.803000000000e-06 6.843129391516e-01
+ 2.804000000000e-06 6.845569006859e-01
+ 2.805000000000e-06 6.848008622202e-01
+ 2.806000000000e-06 6.850448237545e-01
+ 2.807000000000e-06 6.852887852888e-01
+ 2.808000000000e-06 6.855327468231e-01
+ 2.809000000000e-06 6.857767083574e-01
+ 2.810000000000e-06 6.860206698916e-01
+ 2.811000000000e-06 6.862646314259e-01
+ 2.812000000000e-06 6.865085929602e-01
+ 2.813000000000e-06 6.867525544945e-01
+ 2.814000000000e-06 6.869965160288e-01
+ 2.815000000000e-06 6.872404775631e-01
+ 2.816000000000e-06 6.874844390973e-01
+ 2.817000000000e-06 6.877284006316e-01
+ 2.818000000000e-06 6.879723621659e-01
+ 2.819000000000e-06 6.882163237002e-01
+ 2.820000000000e-06 6.884602852345e-01
+ 2.821000000000e-06 6.887042467688e-01
+ 2.822000000000e-06 6.889482083030e-01
+ 2.823000000000e-06 6.891921698373e-01
+ 2.824000000000e-06 6.894361313716e-01
+ 2.825000000000e-06 6.896800929059e-01
+ 2.826000000000e-06 6.899240544402e-01
+ 2.827000000000e-06 6.901680159745e-01
+ 2.828000000000e-06 6.904119775088e-01
+ 2.829000000000e-06 6.906559390430e-01
+ 2.830000000000e-06 6.908999005773e-01
+ 2.831000000000e-06 6.911438621116e-01
+ 2.832000000000e-06 6.913878236459e-01
+ 2.833000000000e-06 6.916317851802e-01
+ 2.834000000000e-06 6.918757467145e-01
+ 2.835000000000e-06 6.921197082487e-01
+ 2.836000000000e-06 6.923636697830e-01
+ 2.837000000000e-06 6.926076313173e-01
+ 2.838000000000e-06 6.928515928516e-01
+ 2.839000000000e-06 6.930955543859e-01
+ 2.840000000000e-06 6.933395159202e-01
+ 2.841000000000e-06 6.935834774544e-01
+ 2.842000000000e-06 6.938274389887e-01
+ 2.843000000000e-06 6.940714005230e-01
+ 2.844000000000e-06 6.943153620573e-01
+ 2.845000000000e-06 6.945593235916e-01
+ 2.846000000000e-06 6.948032851259e-01
+ 2.847000000000e-06 6.950472466601e-01
+ 2.848000000000e-06 6.952912081944e-01
+ 2.849000000000e-06 6.955351697287e-01
+ 2.850000000000e-06 6.957791312630e-01
+ 2.851000000000e-06 6.960230927973e-01
+ 2.852000000000e-06 6.962670543316e-01
+ 2.853000000000e-06 6.965110158659e-01
+ 2.854000000000e-06 6.967549774001e-01
+ 2.855000000000e-06 6.969989389344e-01
+ 2.856000000000e-06 6.972429004687e-01
+ 2.857000000000e-06 6.974868620030e-01
+ 2.858000000000e-06 6.977308235373e-01
+ 2.859000000000e-06 6.979747850716e-01
+ 2.860000000000e-06 6.982187466058e-01
+ 2.861000000000e-06 6.984627081401e-01
+ 2.862000000000e-06 6.987066696744e-01
+ 2.863000000000e-06 6.989506312087e-01
+ 2.864000000000e-06 6.991945927430e-01
+ 2.865000000000e-06 6.994385542773e-01
+ 2.866000000000e-06 6.996825158115e-01
+ 2.867000000000e-06 6.999264773458e-01
+ 2.868000000000e-06 7.001704388801e-01
+ 2.869000000000e-06 7.004144004144e-01
+ 2.870000000000e-06 7.006583619487e-01
+ 2.871000000000e-06 7.009023234830e-01
+ 2.872000000000e-06 7.011462850173e-01
+ 2.873000000000e-06 7.013902465515e-01
+ 2.874000000000e-06 7.016342080858e-01
+ 2.875000000000e-06 7.018781696201e-01
+ 2.876000000000e-06 7.021221311544e-01
+ 2.877000000000e-06 7.023660926887e-01
+ 2.878000000000e-06 7.026100542230e-01
+ 2.879000000000e-06 7.028540157572e-01
+ 2.880000000000e-06 7.030979772915e-01
+ 2.881000000000e-06 7.033419388258e-01
+ 2.882000000000e-06 7.035859003601e-01
+ 2.883000000000e-06 7.038298618944e-01
+ 2.884000000000e-06 7.040738234287e-01
+ 2.885000000000e-06 7.043177849629e-01
+ 2.886000000000e-06 7.045617464972e-01
+ 2.887000000000e-06 7.048057080315e-01
+ 2.888000000000e-06 7.050496695658e-01
+ 2.889000000000e-06 7.052936311001e-01
+ 2.890000000000e-06 7.055375926344e-01
+ 2.891000000000e-06 7.057815541687e-01
+ 2.892000000000e-06 7.060255157029e-01
+ 2.893000000000e-06 7.062694772372e-01
+ 2.894000000000e-06 7.065134387715e-01
+ 2.895000000000e-06 7.067574003058e-01
+ 2.896000000000e-06 7.070013618401e-01
+ 2.897000000000e-06 7.072453233744e-01
+ 2.898000000000e-06 7.074892849086e-01
+ 2.899000000000e-06 7.077332464429e-01
+ 2.900000000000e-06 7.079772079772e-01
+ 2.901000000000e-06 7.082211695115e-01
+ 2.902000000000e-06 7.084651310458e-01
+ 2.903000000000e-06 7.087090925801e-01
+ 2.904000000000e-06 7.089530541143e-01
+ 2.905000000000e-06 7.091970156486e-01
+ 2.906000000000e-06 7.094409771829e-01
+ 2.907000000000e-06 7.096849387172e-01
+ 2.908000000000e-06 7.099289002515e-01
+ 2.909000000000e-06 7.101728617858e-01
+ 2.910000000000e-06 7.104168233200e-01
+ 2.911000000000e-06 7.106607848543e-01
+ 2.912000000000e-06 7.109047463886e-01
+ 2.913000000000e-06 7.111487079229e-01
+ 2.914000000000e-06 7.113926694572e-01
+ 2.915000000000e-06 7.116366309915e-01
+ 2.916000000000e-06 7.118805925258e-01
+ 2.917000000000e-06 7.121245540600e-01
+ 2.918000000000e-06 7.123685155943e-01
+ 2.919000000000e-06 7.126124771286e-01
+ 2.920000000000e-06 7.128564386629e-01
+ 2.921000000000e-06 7.131004001972e-01
+ 2.922000000000e-06 7.133443617315e-01
+ 2.923000000000e-06 7.135883232657e-01
+ 2.924000000000e-06 7.138322848000e-01
+ 2.925000000000e-06 7.140762463343e-01
+ 2.926000000000e-06 7.143202078686e-01
+ 2.927000000000e-06 7.145641694029e-01
+ 2.928000000000e-06 7.148081309372e-01
+ 2.929000000000e-06 7.150520924714e-01
+ 2.930000000000e-06 7.152960540057e-01
+ 2.931000000000e-06 7.155400155400e-01
+ 2.932000000000e-06 7.157839770743e-01
+ 2.933000000000e-06 7.160279386086e-01
+ 2.934000000000e-06 7.162719001429e-01
+ 2.935000000000e-06 7.165158616772e-01
+ 2.936000000000e-06 7.167598232114e-01
+ 2.937000000000e-06 7.170037847457e-01
+ 2.938000000000e-06 7.172477462800e-01
+ 2.939000000000e-06 7.174917078143e-01
+ 2.940000000000e-06 7.177356693486e-01
+ 2.941000000000e-06 7.179796308829e-01
+ 2.942000000000e-06 7.182235924171e-01
+ 2.943000000000e-06 7.184675539514e-01
+ 2.944000000000e-06 7.187115154857e-01
+ 2.945000000000e-06 7.189554770200e-01
+ 2.946000000000e-06 7.191994385543e-01
+ 2.947000000000e-06 7.194434000886e-01
+ 2.948000000000e-06 7.196873616228e-01
+ 2.949000000000e-06 7.199313231571e-01
+ 2.950000000000e-06 7.201752846914e-01
+ 2.951000000000e-06 7.204192462257e-01
+ 2.952000000000e-06 7.206632077600e-01
+ 2.953000000000e-06 7.209071692943e-01
+ 2.954000000000e-06 7.211511308286e-01
+ 2.955000000000e-06 7.213950923628e-01
+ 2.956000000000e-06 7.216390538971e-01
+ 2.957000000000e-06 7.218830154314e-01
+ 2.958000000000e-06 7.221269769657e-01
+ 2.959000000000e-06 7.223709385000e-01
+ 2.960000000000e-06 7.226149000343e-01
+ 2.961000000000e-06 7.228588615685e-01
+ 2.962000000000e-06 7.231028231028e-01
+ 2.963000000000e-06 7.233467846371e-01
+ 2.964000000000e-06 7.235907461714e-01
+ 2.965000000000e-06 7.238347077057e-01
+ 2.966000000000e-06 7.240786692400e-01
+ 2.967000000000e-06 7.243226307742e-01
+ 2.968000000000e-06 7.245665923085e-01
+ 2.969000000000e-06 7.248105538428e-01
+ 2.970000000000e-06 7.250545153771e-01
+ 2.971000000000e-06 7.252984769114e-01
+ 2.972000000000e-06 7.255424384457e-01
+ 2.973000000000e-06 7.257863999799e-01
+ 2.974000000000e-06 7.260303615142e-01
+ 2.975000000000e-06 7.262743230485e-01
+ 2.976000000000e-06 7.265182845828e-01
+ 2.977000000000e-06 7.267622461171e-01
+ 2.978000000000e-06 7.270062076514e-01
+ 2.979000000000e-06 7.272501691857e-01
+ 2.980000000000e-06 7.274941307199e-01
+ 2.981000000000e-06 7.277380922542e-01
+ 2.982000000000e-06 7.279820537885e-01
+ 2.983000000000e-06 7.282260153228e-01
+ 2.984000000000e-06 7.284699768571e-01
+ 2.985000000000e-06 7.287139383914e-01
+ 2.986000000000e-06 7.289578999256e-01
+ 2.987000000000e-06 7.292018614599e-01
+ 2.988000000000e-06 7.294458229942e-01
+ 2.989000000000e-06 7.296897845285e-01
+ 2.990000000000e-06 7.299337460628e-01
+ 2.991000000000e-06 7.301777075971e-01
+ 2.992000000000e-06 7.304216691313e-01
+ 2.993000000000e-06 7.306656306656e-01
+ 2.994000000000e-06 7.309095921999e-01
+ 2.995000000000e-06 7.311535537342e-01
+ 2.996000000000e-06 7.313975152685e-01
+ 2.997000000000e-06 7.316414768028e-01
+ 2.998000000000e-06 7.318854383371e-01
+ 2.999000000000e-06 7.321293998713e-01
+ 3.000000000000e-06 7.323733614056e-01
+ 3.001000000000e-06 7.326173229399e-01
+ 3.002000000000e-06 7.328612844742e-01
+ 3.003000000000e-06 7.331052460085e-01
+ 3.004000000000e-06 7.333492075428e-01
+ 3.005000000000e-06 7.335931690770e-01
+ 3.006000000000e-06 7.338371306113e-01
+ 3.007000000000e-06 7.340810921456e-01
+ 3.008000000000e-06 7.343250536799e-01
+ 3.009000000000e-06 7.345690152142e-01
+ 3.010000000000e-06 7.348129767485e-01
+ 3.011000000000e-06 7.350569382827e-01
+ 3.012000000000e-06 7.353008998170e-01
+ 3.013000000000e-06 7.355448613513e-01
+ 3.014000000000e-06 7.357888228856e-01
+ 3.015000000000e-06 7.360327844199e-01
+ 3.016000000000e-06 7.362767459542e-01
+ 3.017000000000e-06 7.365207074884e-01
+ 3.018000000000e-06 7.367646690227e-01
+ 3.019000000000e-06 7.370086305570e-01
+ 3.020000000000e-06 7.372525920913e-01
+ 3.021000000000e-06 7.374965536256e-01
+ 3.022000000000e-06 7.377405151599e-01
+ 3.023000000000e-06 7.379844766942e-01
+ 3.024000000000e-06 7.382284382284e-01
+ 3.025000000000e-06 7.384723997627e-01
+ 3.026000000000e-06 7.387163612970e-01
+ 3.027000000000e-06 7.389603228313e-01
+ 3.028000000000e-06 7.392042843656e-01
+ 3.029000000000e-06 7.394482458999e-01
+ 3.030000000000e-06 7.396922074341e-01
+ 3.031000000000e-06 7.399361689684e-01
+ 3.032000000000e-06 7.401801305027e-01
+ 3.033000000000e-06 7.404240920370e-01
+ 3.034000000000e-06 7.406680535713e-01
+ 3.035000000000e-06 7.409120151056e-01
+ 3.036000000000e-06 7.411559766398e-01
+ 3.037000000000e-06 7.413999381741e-01
+ 3.038000000000e-06 7.416438997084e-01
+ 3.039000000000e-06 7.418878612427e-01
+ 3.040000000000e-06 7.421318227770e-01
+ 3.041000000000e-06 7.423757843113e-01
+ 3.042000000000e-06 7.426197458456e-01
+ 3.043000000000e-06 7.428637073798e-01
+ 3.044000000000e-06 7.431076689141e-01
+ 3.045000000000e-06 7.433516304484e-01
+ 3.046000000000e-06 7.435955919827e-01
+ 3.047000000000e-06 7.438395535170e-01
+ 3.048000000000e-06 7.440835150513e-01
+ 3.049000000000e-06 7.443274765855e-01
+ 3.050000000000e-06 7.445714381198e-01
+ 3.051000000000e-06 7.448153996541e-01
+ 3.052000000000e-06 7.450593611884e-01
+ 3.053000000000e-06 7.453033227227e-01
+ 3.054000000000e-06 7.455472842570e-01
+ 3.055000000000e-06 7.457912457912e-01
+ 3.056000000000e-06 7.460352073255e-01
+ 3.057000000000e-06 7.462791688598e-01
+ 3.058000000000e-06 7.465231303941e-01
+ 3.059000000000e-06 7.467670919284e-01
+ 3.060000000000e-06 7.470110534627e-01
+ 3.061000000000e-06 7.472550149970e-01
+ 3.062000000000e-06 7.474989765312e-01
+ 3.063000000000e-06 7.477429380655e-01
+ 3.064000000000e-06 7.479868995998e-01
+ 3.065000000000e-06 7.482308611341e-01
+ 3.066000000000e-06 7.484748226684e-01
+ 3.067000000000e-06 7.487187842027e-01
+ 3.068000000000e-06 7.489627457369e-01
+ 3.069000000000e-06 7.492067072712e-01
+ 3.070000000000e-06 7.494506688055e-01
+ 3.071000000000e-06 7.496946303398e-01
+ 3.072000000000e-06 7.499385918741e-01
+ 3.073000000000e-06 7.501825534084e-01
+ 3.074000000000e-06 7.504265149426e-01
+ 3.075000000000e-06 7.506704764769e-01
+ 3.076000000000e-06 7.509144380112e-01
+ 3.077000000000e-06 7.511583995455e-01
+ 3.078000000000e-06 7.514023610798e-01
+ 3.079000000000e-06 7.516463226141e-01
+ 3.080000000000e-06 7.518902841483e-01
+ 3.081000000000e-06 7.521342456826e-01
+ 3.082000000000e-06 7.523782072169e-01
+ 3.083000000000e-06 7.526221687512e-01
+ 3.084000000000e-06 7.528661302855e-01
+ 3.085000000000e-06 7.531100918198e-01
+ 3.086000000000e-06 7.533540533541e-01
+ 3.087000000000e-06 7.535980148883e-01
+ 3.088000000000e-06 7.538419764226e-01
+ 3.089000000000e-06 7.540859379569e-01
+ 3.090000000000e-06 7.543298994912e-01
+ 3.091000000000e-06 7.545738610255e-01
+ 3.092000000000e-06 7.548178225598e-01
+ 3.093000000000e-06 7.550617840940e-01
+ 3.094000000000e-06 7.553057456283e-01
+ 3.095000000000e-06 7.555497071626e-01
+ 3.096000000000e-06 7.557936686969e-01
+ 3.097000000000e-06 7.560376302312e-01
+ 3.098000000000e-06 7.562815917655e-01
+ 3.099000000000e-06 7.565255532997e-01
+ 3.100000000000e-06 7.567695148340e-01
+ 3.101000000000e-06 7.570134763683e-01
+ 3.102000000000e-06 7.572574379026e-01
+ 3.103000000000e-06 7.575013994369e-01
+ 3.104000000000e-06 7.577453609712e-01
+ 3.105000000000e-06 7.579893225055e-01
+ 3.106000000000e-06 7.582332840397e-01
+ 3.107000000000e-06 7.584772455740e-01
+ 3.108000000000e-06 7.587212071083e-01
+ 3.109000000000e-06 7.589651686426e-01
+ 3.110000000000e-06 7.592091301769e-01
+ 3.111000000000e-06 7.594530917112e-01
+ 3.112000000000e-06 7.596970532454e-01
+ 3.113000000000e-06 7.599410147797e-01
+ 3.114000000000e-06 7.601849763140e-01
+ 3.115000000000e-06 7.604289378483e-01
+ 3.116000000000e-06 7.606728993826e-01
+ 3.117000000000e-06 7.609168609169e-01
+ 3.118000000000e-06 7.611608224511e-01
+ 3.119000000000e-06 7.614047839854e-01
+ 3.120000000000e-06 7.616487455197e-01
+ 3.121000000000e-06 7.618927070540e-01
+ 3.122000000000e-06 7.621366685883e-01
+ 3.123000000000e-06 7.623806301226e-01
+ 3.124000000000e-06 7.626245916568e-01
+ 3.125000000000e-06 7.628685531911e-01
+ 3.126000000000e-06 7.631125147254e-01
+ 3.127000000000e-06 7.633564762597e-01
+ 3.128000000000e-06 7.636004377940e-01
+ 3.129000000000e-06 7.638443993283e-01
+ 3.130000000000e-06 7.640883608626e-01
+ 3.131000000000e-06 7.643323223968e-01
+ 3.132000000000e-06 7.645762839311e-01
+ 3.133000000000e-06 7.648202454654e-01
+ 3.134000000000e-06 7.650642069997e-01
+ 3.135000000000e-06 7.653081685340e-01
+ 3.136000000000e-06 7.655521300683e-01
+ 3.137000000000e-06 7.657960916025e-01
+ 3.138000000000e-06 7.660400531368e-01
+ 3.139000000000e-06 7.662840146711e-01
+ 3.140000000000e-06 7.665279762054e-01
+ 3.141000000000e-06 7.667719377397e-01
+ 3.142000000000e-06 7.670158992740e-01
+ 3.143000000000e-06 7.672598608082e-01
+ 3.144000000000e-06 7.675038223425e-01
+ 3.145000000000e-06 7.677477838768e-01
+ 3.146000000000e-06 7.679917454111e-01
+ 3.147000000000e-06 7.682357069454e-01
+ 3.148000000000e-06 7.684796684797e-01
+ 3.149000000000e-06 7.687236300140e-01
+ 3.150000000000e-06 7.689675915482e-01
+ 3.151000000000e-06 7.692115530825e-01
+ 3.152000000000e-06 7.694555146168e-01
+ 3.153000000000e-06 7.696994761511e-01
+ 3.154000000000e-06 7.699434376854e-01
+ 3.155000000000e-06 7.701873992197e-01
+ 3.156000000000e-06 7.704313607539e-01
+ 3.157000000000e-06 7.706753222882e-01
+ 3.158000000000e-06 7.709192838225e-01
+ 3.159000000000e-06 7.711632453568e-01
+ 3.160000000000e-06 7.714072068911e-01
+ 3.161000000000e-06 7.716511684254e-01
+ 3.162000000000e-06 7.718951299596e-01
+ 3.163000000000e-06 7.721390914939e-01
+ 3.164000000000e-06 7.723830530282e-01
+ 3.165000000000e-06 7.726270145625e-01
+ 3.166000000000e-06 7.728709760968e-01
+ 3.167000000000e-06 7.731149376311e-01
+ 3.168000000000e-06 7.733588991654e-01
+ 3.169000000000e-06 7.736028606996e-01
+ 3.170000000000e-06 7.738468222339e-01
+ 3.171000000000e-06 7.740907837682e-01
+ 3.172000000000e-06 7.743347453025e-01
+ 3.173000000000e-06 7.745787068368e-01
+ 3.174000000000e-06 7.748226683711e-01
+ 3.175000000000e-06 7.750666299053e-01
+ 3.176000000000e-06 7.753105914396e-01
+ 3.177000000000e-06 7.755545529739e-01
+ 3.178000000000e-06 7.757985145082e-01
+ 3.179000000000e-06 7.760424760425e-01
+ 3.180000000000e-06 7.762864375768e-01
+ 3.181000000000e-06 7.765303991110e-01
+ 3.182000000000e-06 7.767743606453e-01
+ 3.183000000000e-06 7.770183221796e-01
+ 3.184000000000e-06 7.772622837139e-01
+ 3.185000000000e-06 7.775062452482e-01
+ 3.186000000000e-06 7.777502067825e-01
+ 3.187000000000e-06 7.779941683167e-01
+ 3.188000000000e-06 7.782381298510e-01
+ 3.189000000000e-06 7.784820913853e-01
+ 3.190000000000e-06 7.787260529196e-01
+ 3.191000000000e-06 7.789700144539e-01
+ 3.192000000000e-06 7.792139759882e-01
+ 3.193000000000e-06 7.794579375225e-01
+ 3.194000000000e-06 7.797018990567e-01
+ 3.195000000000e-06 7.799458605910e-01
+ 3.196000000000e-06 7.801898221253e-01
+ 3.197000000000e-06 7.804337836596e-01
+ 3.198000000000e-06 7.806777451939e-01
+ 3.199000000000e-06 7.809217067282e-01
+ 3.200000000000e-06 7.811656682624e-01
+ 3.201000000000e-06 7.814096297967e-01
+ 3.202000000000e-06 7.816535913310e-01
+ 3.203000000000e-06 7.818975528653e-01
+ 3.204000000000e-06 7.821415143996e-01
+ 3.205000000000e-06 7.823854759339e-01
+ 3.206000000000e-06 7.826294374681e-01
+ 3.207000000000e-06 7.828733990024e-01
+ 3.208000000000e-06 7.831173605367e-01
+ 3.209000000000e-06 7.833613220710e-01
+ 3.210000000000e-06 7.836052836053e-01
+ 3.211000000000e-06 7.838492451396e-01
+ 3.212000000000e-06 7.840932066739e-01
+ 3.213000000000e-06 7.843371682081e-01
+ 3.214000000000e-06 7.845811297424e-01
+ 3.215000000000e-06 7.848250912767e-01
+ 3.216000000000e-06 7.850690528110e-01
+ 3.217000000000e-06 7.853130143453e-01
+ 3.218000000000e-06 7.855569758796e-01
+ 3.219000000000e-06 7.858009374138e-01
+ 3.220000000000e-06 7.860448989481e-01
+ 3.221000000000e-06 7.862888604824e-01
+ 3.222000000000e-06 7.865328220167e-01
+ 3.223000000000e-06 7.867767835510e-01
+ 3.224000000000e-06 7.870207450853e-01
+ 3.225000000000e-06 7.872647066195e-01
+ 3.226000000000e-06 7.875086681538e-01
+ 3.227000000000e-06 7.877526296881e-01
+ 3.228000000000e-06 7.879965912224e-01
+ 3.229000000000e-06 7.882405527567e-01
+ 3.230000000000e-06 7.884845142910e-01
+ 3.231000000000e-06 7.887284758252e-01
+ 3.232000000000e-06 7.889724373595e-01
+ 3.233000000000e-06 7.892163988938e-01
+ 3.234000000000e-06 7.894603604281e-01
+ 3.235000000000e-06 7.897043219624e-01
+ 3.236000000000e-06 7.899482834967e-01
+ 3.237000000000e-06 7.901922450310e-01
+ 3.238000000000e-06 7.904362065652e-01
+ 3.239000000000e-06 7.906801680995e-01
+ 3.240000000000e-06 7.909241296338e-01
+ 3.241000000000e-06 7.911680911681e-01
+ 3.242000000000e-06 7.914120527024e-01
+ 3.243000000000e-06 7.916560142367e-01
+ 3.244000000000e-06 7.918999757709e-01
+ 3.245000000000e-06 7.921439373052e-01
+ 3.246000000000e-06 7.923878988395e-01
+ 3.247000000000e-06 7.926318603738e-01
+ 3.248000000000e-06 7.928758219081e-01
+ 3.249000000000e-06 7.931197834424e-01
+ 3.250000000000e-06 7.933637449766e-01
+ 3.251000000000e-06 7.936077065109e-01
+ 3.252000000000e-06 7.938516680452e-01
+ 3.253000000000e-06 7.940956295795e-01
+ 3.254000000000e-06 7.943395911138e-01
+ 3.255000000000e-06 7.945835526481e-01
+ 3.256000000000e-06 7.948275141824e-01
+ 3.257000000000e-06 7.950714757166e-01
+ 3.258000000000e-06 7.953154372509e-01
+ 3.259000000000e-06 7.955593987852e-01
+ 3.260000000000e-06 7.958033603195e-01
+ 3.261000000000e-06 7.960473218538e-01
+ 3.262000000000e-06 7.962912833881e-01
+ 3.263000000000e-06 7.965352449223e-01
+ 3.264000000000e-06 7.967792064566e-01
+ 3.265000000000e-06 7.970231679909e-01
+ 3.266000000000e-06 7.972671295252e-01
+ 3.267000000000e-06 7.975110910595e-01
+ 3.268000000000e-06 7.977550525938e-01
+ 3.269000000000e-06 7.979990141280e-01
+ 3.270000000000e-06 7.982429756623e-01
+ 3.271000000000e-06 7.984869371966e-01
+ 3.272000000000e-06 7.987308987309e-01
+ 3.273000000000e-06 7.989748602652e-01
+ 3.274000000000e-06 7.992188217995e-01
+ 3.275000000000e-06 7.994627833338e-01
+ 3.276000000000e-06 7.997067448680e-01
+ 3.277000000000e-06 7.999507064023e-01
+ 3.278000000000e-06 8.001946679366e-01
+ 3.279000000000e-06 8.004386294709e-01
+ 3.280000000000e-06 8.006825910052e-01
+ 3.281000000000e-06 8.009265525395e-01
+ 3.282000000000e-06 8.011705140737e-01
+ 3.283000000000e-06 8.014144756080e-01
+ 3.284000000000e-06 8.016584371423e-01
+ 3.285000000000e-06 8.019023986766e-01
+ 3.286000000000e-06 8.021463602109e-01
+ 3.287000000000e-06 8.023903217452e-01
+ 3.288000000000e-06 8.026342832794e-01
+ 3.289000000000e-06 8.028782448137e-01
+ 3.290000000000e-06 8.031222063480e-01
+ 3.291000000000e-06 8.033661678823e-01
+ 3.292000000000e-06 8.036101294166e-01
+ 3.293000000000e-06 8.038540909509e-01
+ 3.294000000000e-06 8.040980524851e-01
+ 3.295000000000e-06 8.043420140194e-01
+ 3.296000000000e-06 8.045859755537e-01
+ 3.297000000000e-06 8.048299370880e-01
+ 3.298000000000e-06 8.050738986223e-01
+ 3.299000000000e-06 8.053178601566e-01
+ 3.300000000000e-06 8.055618216909e-01
+ 3.301000000000e-06 8.058057832251e-01
+ 3.302000000000e-06 8.060497447594e-01
+ 3.303000000000e-06 8.062937062937e-01
+ 3.304000000000e-06 8.065376678280e-01
+ 3.305000000000e-06 8.067816293623e-01
+ 3.306000000000e-06 8.070255908966e-01
+ 3.307000000000e-06 8.072695524308e-01
+ 3.308000000000e-06 8.075135139651e-01
+ 3.309000000000e-06 8.077574754994e-01
+ 3.310000000000e-06 8.080014370337e-01
+ 3.311000000000e-06 8.082453985680e-01
+ 3.312000000000e-06 8.084893601023e-01
+ 3.313000000000e-06 8.087333216365e-01
+ 3.314000000000e-06 8.089772831708e-01
+ 3.315000000000e-06 8.092212447051e-01
+ 3.316000000000e-06 8.094652062394e-01
+ 3.317000000000e-06 8.097091677737e-01
+ 3.318000000000e-06 8.099531293080e-01
+ 3.319000000000e-06 8.101970908423e-01
+ 3.320000000000e-06 8.104410523765e-01
+ 3.321000000000e-06 8.106850139108e-01
+ 3.322000000000e-06 8.109289754451e-01
+ 3.323000000000e-06 8.111729369794e-01
+ 3.324000000000e-06 8.114168985137e-01
+ 3.325000000000e-06 8.116608600480e-01
+ 3.326000000000e-06 8.119048215822e-01
+ 3.327000000000e-06 8.121487831165e-01
+ 3.328000000000e-06 8.123927446508e-01
+ 3.329000000000e-06 8.126367061851e-01
+ 3.330000000000e-06 8.128806677194e-01
+ 3.331000000000e-06 8.131246292537e-01
+ 3.332000000000e-06 8.133685907879e-01
+ 3.333000000000e-06 8.136125523222e-01
+ 3.334000000000e-06 8.138565138565e-01
+ 3.335000000000e-06 8.141004753908e-01
+ 3.336000000000e-06 8.143444369251e-01
+ 3.337000000000e-06 8.145883984594e-01
+ 3.338000000000e-06 8.148323599937e-01
+ 3.339000000000e-06 8.150763215279e-01
+ 3.340000000000e-06 8.153202830622e-01
+ 3.341000000000e-06 8.155642445965e-01
+ 3.342000000000e-06 8.158082061308e-01
+ 3.343000000000e-06 8.160521676651e-01
+ 3.344000000000e-06 8.162961291994e-01
+ 3.345000000000e-06 8.165400907336e-01
+ 3.346000000000e-06 8.167840522679e-01
+ 3.347000000000e-06 8.170280138022e-01
+ 3.348000000000e-06 8.172719753365e-01
+ 3.349000000000e-06 8.175159368708e-01
+ 3.350000000000e-06 8.177598984051e-01
+ 3.351000000000e-06 8.180038599393e-01
+ 3.352000000000e-06 8.182478214736e-01
+ 3.353000000000e-06 8.184917830079e-01
+ 3.354000000000e-06 8.187357445422e-01
+ 3.355000000000e-06 8.189797060765e-01
+ 3.356000000000e-06 8.192236676108e-01
+ 3.357000000000e-06 8.194676291450e-01
+ 3.358000000000e-06 8.197115906793e-01
+ 3.359000000000e-06 8.199555522136e-01
+ 3.360000000000e-06 8.201995137479e-01
+ 3.361000000000e-06 8.204434752822e-01
+ 3.362000000000e-06 8.206874368165e-01
+ 3.363000000000e-06 8.209313983508e-01
+ 3.364000000000e-06 8.211753598850e-01
+ 3.365000000000e-06 8.214193214193e-01
+ 3.366000000000e-06 8.216632829536e-01
+ 3.367000000000e-06 8.219072444879e-01
+ 3.368000000000e-06 8.221512060222e-01
+ 3.369000000000e-06 8.223951675565e-01
+ 3.370000000000e-06 8.226391290907e-01
+ 3.371000000000e-06 8.228830906250e-01
+ 3.372000000000e-06 8.231270521593e-01
+ 3.373000000000e-06 8.233710136936e-01
+ 3.374000000000e-06 8.236149752279e-01
+ 3.375000000000e-06 8.238589367622e-01
+ 3.376000000000e-06 8.241028982964e-01
+ 3.377000000000e-06 8.243468598307e-01
+ 3.378000000000e-06 8.245908213650e-01
+ 3.379000000000e-06 8.248347828993e-01
+ 3.380000000000e-06 8.250787444336e-01
+ 3.381000000000e-06 8.253227059679e-01
+ 3.382000000000e-06 8.255666675022e-01
+ 3.383000000000e-06 8.258106290364e-01
+ 3.384000000000e-06 8.260545905707e-01
+ 3.385000000000e-06 8.262985521050e-01
+ 3.386000000000e-06 8.265425136393e-01
+ 3.387000000000e-06 8.267864751736e-01
+ 3.388000000000e-06 8.270304367079e-01
+ 3.389000000000e-06 8.272743982421e-01
+ 3.390000000000e-06 8.275183597764e-01
+ 3.391000000000e-06 8.277623213107e-01
+ 3.392000000000e-06 8.280062828450e-01
+ 3.393000000000e-06 8.282502443793e-01
+ 3.394000000000e-06 8.284942059136e-01
+ 3.395000000000e-06 8.287381674478e-01
+ 3.396000000000e-06 8.289821289821e-01
+ 3.397000000000e-06 8.292260905164e-01
+ 3.398000000000e-06 8.294700520507e-01
+ 3.399000000000e-06 8.297140135850e-01
+ 3.400000000000e-06 8.299579751193e-01
+ 3.401000000000e-06 8.302019366535e-01
+ 3.402000000000e-06 8.304458981878e-01
+ 3.403000000000e-06 8.306898597221e-01
+ 3.404000000000e-06 8.309338212564e-01
+ 3.405000000000e-06 8.311777827907e-01
+ 3.406000000000e-06 8.314217443250e-01
+ 3.407000000000e-06 8.316657058593e-01
+ 3.408000000000e-06 8.319096673935e-01
+ 3.409000000000e-06 8.321536289278e-01
+ 3.410000000000e-06 8.323975904621e-01
+ 3.411000000000e-06 8.326415519964e-01
+ 3.412000000000e-06 8.328855135307e-01
+ 3.413000000000e-06 8.331294750650e-01
+ 3.414000000000e-06 8.333734365992e-01
+ 3.415000000000e-06 8.336173981335e-01
+ 3.416000000000e-06 8.338613596678e-01
+ 3.417000000000e-06 8.341053212021e-01
+ 3.418000000000e-06 8.343492827364e-01
+ 3.419000000000e-06 8.345932442707e-01
+ 3.420000000000e-06 8.348372058049e-01
+ 3.421000000000e-06 8.350811673392e-01
+ 3.422000000000e-06 8.353251288735e-01
+ 3.423000000000e-06 8.355690904078e-01
+ 3.424000000000e-06 8.358130519421e-01
+ 3.425000000000e-06 8.360570134764e-01
+ 3.426000000000e-06 8.363009750107e-01
+ 3.427000000000e-06 8.365449365449e-01
+ 3.428000000000e-06 8.367888980792e-01
+ 3.429000000000e-06 8.370328596135e-01
+ 3.430000000000e-06 8.372768211478e-01
+ 3.431000000000e-06 8.375207826821e-01
+ 3.432000000000e-06 8.377647442164e-01
+ 3.433000000000e-06 8.380087057506e-01
+ 3.434000000000e-06 8.382526672849e-01
+ 3.435000000000e-06 8.384966288192e-01
+ 3.436000000000e-06 8.387405903535e-01
+ 3.437000000000e-06 8.389845518878e-01
+ 3.438000000000e-06 8.392285134221e-01
+ 3.439000000000e-06 8.394724749563e-01
+ 3.440000000000e-06 8.397164364906e-01
+ 3.441000000000e-06 8.399603980249e-01
+ 3.442000000000e-06 8.402043595592e-01
+ 3.443000000000e-06 8.404483210935e-01
+ 3.444000000000e-06 8.406922826278e-01
+ 3.445000000000e-06 8.409362441621e-01
+ 3.446000000000e-06 8.411802056963e-01
+ 3.447000000000e-06 8.414241672306e-01
+ 3.448000000000e-06 8.416681287649e-01
+ 3.449000000000e-06 8.419120902992e-01
+ 3.450000000000e-06 8.421560518335e-01
+ 3.451000000000e-06 8.424000133678e-01
+ 3.452000000000e-06 8.426439749020e-01
+ 3.453000000000e-06 8.428879364363e-01
+ 3.454000000000e-06 8.431318979706e-01
+ 3.455000000000e-06 8.433758595049e-01
+ 3.456000000000e-06 8.436198210392e-01
+ 3.457000000000e-06 8.438637825735e-01
+ 3.458000000000e-06 8.441077441077e-01
+ 3.459000000000e-06 8.443517056420e-01
+ 3.460000000000e-06 8.445956671763e-01
+ 3.461000000000e-06 8.448396287106e-01
+ 3.462000000000e-06 8.450835902449e-01
+ 3.463000000000e-06 8.453275517792e-01
+ 3.464000000000e-06 8.455715133134e-01
+ 3.465000000000e-06 8.458154748477e-01
+ 3.466000000000e-06 8.460594363820e-01
+ 3.467000000000e-06 8.463033979163e-01
+ 3.468000000000e-06 8.465473594506e-01
+ 3.469000000000e-06 8.467913209849e-01
+ 3.470000000000e-06 8.470352825192e-01
+ 3.471000000000e-06 8.472792440534e-01
+ 3.472000000000e-06 8.475232055877e-01
+ 3.473000000000e-06 8.477671671220e-01
+ 3.474000000000e-06 8.480111286563e-01
+ 3.475000000000e-06 8.482550901906e-01
+ 3.476000000000e-06 8.484990517249e-01
+ 3.477000000000e-06 8.487430132591e-01
+ 3.478000000000e-06 8.489869747934e-01
+ 3.479000000000e-06 8.492309363277e-01
+ 3.480000000000e-06 8.494748978620e-01
+ 3.481000000000e-06 8.497188593963e-01
+ 3.482000000000e-06 8.499628209306e-01
+ 3.483000000000e-06 8.502067824648e-01
+ 3.484000000000e-06 8.504507439991e-01
+ 3.485000000000e-06 8.506947055334e-01
+ 3.486000000000e-06 8.509386670677e-01
+ 3.487000000000e-06 8.511826286020e-01
+ 3.488000000000e-06 8.514265901363e-01
+ 3.489000000000e-06 8.516705516706e-01
+ 3.490000000000e-06 8.519145132048e-01
+ 3.491000000000e-06 8.521584747391e-01
+ 3.492000000000e-06 8.524024362734e-01
+ 3.493000000000e-06 8.526463978077e-01
+ 3.494000000000e-06 8.528903593420e-01
+ 3.495000000000e-06 8.531343208763e-01
+ 3.496000000000e-06 8.533782824105e-01
+ 3.497000000000e-06 8.536222439448e-01
+ 3.498000000000e-06 8.538662054791e-01
+ 3.499000000000e-06 8.541101670134e-01
+ 3.500000000000e-06 8.543541285477e-01
+ 3.501000000000e-06 8.545980900820e-01
+ 3.502000000000e-06 8.548420516162e-01
+ 3.503000000000e-06 8.550860131505e-01
+ 3.504000000000e-06 8.553299746848e-01
+ 3.505000000000e-06 8.555739362191e-01
+ 3.506000000000e-06 8.558178977534e-01
+ 3.507000000000e-06 8.560618592877e-01
+ 3.508000000000e-06 8.563058208219e-01
+ 3.509000000000e-06 8.565497823562e-01
+ 3.510000000000e-06 8.567937438905e-01
+ 3.511000000000e-06 8.570377054248e-01
+ 3.512000000000e-06 8.572816669591e-01
+ 3.513000000000e-06 8.575256284934e-01
+ 3.514000000000e-06 8.577695900277e-01
+ 3.515000000000e-06 8.580135515619e-01
+ 3.516000000000e-06 8.582575130962e-01
+ 3.517000000000e-06 8.585014746305e-01
+ 3.518000000000e-06 8.587454361648e-01
+ 3.519000000000e-06 8.589893976991e-01
+ 3.520000000000e-06 8.592333592334e-01
+ 3.521000000000e-06 8.594773207676e-01
+ 3.522000000000e-06 8.597212823019e-01
+ 3.523000000000e-06 8.599652438362e-01
+ 3.524000000000e-06 8.602092053705e-01
+ 3.525000000000e-06 8.604531669048e-01
+ 3.526000000000e-06 8.606971284391e-01
+ 3.527000000000e-06 8.609410899733e-01
+ 3.528000000000e-06 8.611850515076e-01
+ 3.529000000000e-06 8.614290130419e-01
+ 3.530000000000e-06 8.616729745762e-01
+ 3.531000000000e-06 8.619169361105e-01
+ 3.532000000000e-06 8.621608976448e-01
+ 3.533000000000e-06 8.624048591791e-01
+ 3.534000000000e-06 8.626488207133e-01
+ 3.535000000000e-06 8.628927822476e-01
+ 3.536000000000e-06 8.631367437819e-01
+ 3.537000000000e-06 8.633807053162e-01
+ 3.538000000000e-06 8.636246668505e-01
+ 3.539000000000e-06 8.638686283848e-01
+ 3.540000000000e-06 8.641125899190e-01
+ 3.541000000000e-06 8.643565514533e-01
+ 3.542000000000e-06 8.646005129876e-01
+ 3.543000000000e-06 8.648444745219e-01
+ 3.544000000000e-06 8.650884360562e-01
+ 3.545000000000e-06 8.653323975905e-01
+ 3.546000000000e-06 8.655763591247e-01
+ 3.547000000000e-06 8.658203206590e-01
+ 3.548000000000e-06 8.660642821933e-01
+ 3.549000000000e-06 8.663082437276e-01
+ 3.550000000000e-06 8.665522052619e-01
+ 3.551000000000e-06 8.667961667962e-01
+ 3.552000000000e-06 8.670401283305e-01
+ 3.553000000000e-06 8.672840898647e-01
+ 3.554000000000e-06 8.675280513990e-01
+ 3.555000000000e-06 8.677720129333e-01
+ 3.556000000000e-06 8.680159744676e-01
+ 3.557000000000e-06 8.682599360019e-01
+ 3.558000000000e-06 8.685038975362e-01
+ 3.559000000000e-06 8.687478590704e-01
+ 3.560000000000e-06 8.689918206047e-01
+ 3.561000000000e-06 8.692357821390e-01
+ 3.562000000000e-06 8.694797436733e-01
+ 3.563000000000e-06 8.697237052076e-01
+ 3.564000000000e-06 8.699676667419e-01
+ 3.565000000000e-06 8.702116282761e-01
+ 3.566000000000e-06 8.704555898104e-01
+ 3.567000000000e-06 8.706995513447e-01
+ 3.568000000000e-06 8.709435128790e-01
+ 3.569000000000e-06 8.711874744133e-01
+ 3.570000000000e-06 8.714314359476e-01
+ 3.571000000000e-06 8.716753974818e-01
+ 3.572000000000e-06 8.719193590161e-01
+ 3.573000000000e-06 8.721633205504e-01
+ 3.574000000000e-06 8.724072820847e-01
+ 3.575000000000e-06 8.726512436190e-01
+ 3.576000000000e-06 8.728952051533e-01
+ 3.577000000000e-06 8.731391666876e-01
+ 3.578000000000e-06 8.733831282218e-01
+ 3.579000000000e-06 8.736270897561e-01
+ 3.580000000000e-06 8.738710512904e-01
+ 3.581000000000e-06 8.741150128247e-01
+ 3.582000000000e-06 8.743589743590e-01
+ 3.583000000000e-06 8.746029358933e-01
+ 3.584000000000e-06 8.748468974275e-01
+ 3.585000000000e-06 8.750908589618e-01
+ 3.586000000000e-06 8.753348204961e-01
+ 3.587000000000e-06 8.755787820304e-01
+ 3.588000000000e-06 8.758227435647e-01
+ 3.589000000000e-06 8.760667050990e-01
+ 3.590000000000e-06 8.763106666332e-01
+ 3.591000000000e-06 8.765546281675e-01
+ 3.592000000000e-06 8.767985897018e-01
+ 3.593000000000e-06 8.770425512361e-01
+ 3.594000000000e-06 8.772865127704e-01
+ 3.595000000000e-06 8.775304743047e-01
+ 3.596000000000e-06 8.777744358390e-01
+ 3.597000000000e-06 8.780183973732e-01
+ 3.598000000000e-06 8.782623589075e-01
+ 3.599000000000e-06 8.785063204418e-01
+ 3.600000000000e-06 8.787502819761e-01
+ 3.601000000000e-06 8.789942435104e-01
+ 3.602000000000e-06 8.792382050447e-01
+ 3.603000000000e-06 8.794821665789e-01
+ 3.604000000000e-06 8.797261281132e-01
+ 3.605000000000e-06 8.799700896475e-01
+ 3.606000000000e-06 8.802140511818e-01
+ 3.607000000000e-06 8.804580127161e-01
+ 3.608000000000e-06 8.807019742504e-01
+ 3.609000000000e-06 8.809459357846e-01
+ 3.610000000000e-06 8.811898973189e-01
+ 3.611000000000e-06 8.814338588532e-01
+ 3.612000000000e-06 8.816778203875e-01
+ 3.613000000000e-06 8.819217819218e-01
+ 3.614000000000e-06 8.821657434561e-01
+ 3.615000000000e-06 8.824097049904e-01
+ 3.616000000000e-06 8.826536665246e-01
+ 3.617000000000e-06 8.828976280589e-01
+ 3.618000000000e-06 8.831415895932e-01
+ 3.619000000000e-06 8.833855511275e-01
+ 3.620000000000e-06 8.836295126618e-01
+ 3.621000000000e-06 8.838734741961e-01
+ 3.622000000000e-06 8.841174357303e-01
+ 3.623000000000e-06 8.843613972646e-01
+ 3.624000000000e-06 8.846053587989e-01
+ 3.625000000000e-06 8.848493203332e-01
+ 3.626000000000e-06 8.850932818675e-01
+ 3.627000000000e-06 8.853372434018e-01
+ 3.628000000000e-06 8.855812049360e-01
+ 3.629000000000e-06 8.858251664703e-01
+ 3.630000000000e-06 8.860691280046e-01
+ 3.631000000000e-06 8.863130895389e-01
+ 3.632000000000e-06 8.865570510732e-01
+ 3.633000000000e-06 8.868010126075e-01
+ 3.634000000000e-06 8.870449741417e-01
+ 3.635000000000e-06 8.872889356760e-01
+ 3.636000000000e-06 8.875328972103e-01
+ 3.637000000000e-06 8.877768587446e-01
+ 3.638000000000e-06 8.880208202789e-01
+ 3.639000000000e-06 8.882647818132e-01
+ 3.640000000000e-06 8.885087433475e-01
+ 3.641000000000e-06 8.887527048817e-01
+ 3.642000000000e-06 8.889966664160e-01
+ 3.643000000000e-06 8.892406279503e-01
+ 3.644000000000e-06 8.894845894846e-01
+ 3.645000000000e-06 8.897285510189e-01
+ 3.646000000000e-06 8.899725125532e-01
+ 3.647000000000e-06 8.902164740874e-01
+ 3.648000000000e-06 8.904604356217e-01
+ 3.649000000000e-06 8.907043971560e-01
+ 3.650000000000e-06 8.909483586903e-01
+ 3.651000000000e-06 8.911923202246e-01
+ 3.652000000000e-06 8.914362817589e-01
+ 3.653000000000e-06 8.916802432931e-01
+ 3.654000000000e-06 8.919242048274e-01
+ 3.655000000000e-06 8.921681663617e-01
+ 3.656000000000e-06 8.924121278960e-01
+ 3.657000000000e-06 8.926560894303e-01
+ 3.658000000000e-06 8.929000509646e-01
+ 3.659000000000e-06 8.931440124989e-01
+ 3.660000000000e-06 8.933879740331e-01
+ 3.661000000000e-06 8.936319355674e-01
+ 3.662000000000e-06 8.938758971017e-01
+ 3.663000000000e-06 8.941198586360e-01
+ 3.664000000000e-06 8.943638201703e-01
+ 3.665000000000e-06 8.946077817046e-01
+ 3.666000000000e-06 8.948517432388e-01
+ 3.667000000000e-06 8.950957047731e-01
+ 3.668000000000e-06 8.953396663074e-01
+ 3.669000000000e-06 8.955836278417e-01
+ 3.670000000000e-06 8.958275893760e-01
+ 3.671000000000e-06 8.960715509103e-01
+ 3.672000000000e-06 8.963155124445e-01
+ 3.673000000000e-06 8.965594739788e-01
+ 3.674000000000e-06 8.968034355131e-01
+ 3.675000000000e-06 8.970473970474e-01
+ 3.676000000000e-06 8.972913585817e-01
+ 3.677000000000e-06 8.975353201160e-01
+ 3.678000000000e-06 8.977792816502e-01
+ 3.679000000000e-06 8.980232431845e-01
+ 3.680000000000e-06 8.982672047188e-01
+ 3.681000000000e-06 8.985111662531e-01
+ 3.682000000000e-06 8.987551277874e-01
+ 3.683000000000e-06 8.989990893217e-01
+ 3.684000000000e-06 8.992430508560e-01
+ 3.685000000000e-06 8.994870123902e-01
+ 3.686000000000e-06 8.997309739245e-01
+ 3.687000000000e-06 8.999749354588e-01
+ 3.688000000000e-06 9.002188969931e-01
+ 3.689000000000e-06 9.004628585274e-01
+ 3.690000000000e-06 9.007068200617e-01
+ 3.691000000000e-06 9.009507815959e-01
+ 3.692000000000e-06 9.011947431302e-01
+ 3.693000000000e-06 9.014387046645e-01
+ 3.694000000000e-06 9.016826661988e-01
+ 3.695000000000e-06 9.019266277331e-01
+ 3.696000000000e-06 9.021705892674e-01
+ 3.697000000000e-06 9.024145508016e-01
+ 3.698000000000e-06 9.026585123359e-01
+ 3.699000000000e-06 9.029024738702e-01
+ 3.700000000000e-06 9.031464354045e-01
+ 3.701000000000e-06 9.033903969388e-01
+ 3.702000000000e-06 9.036343584731e-01
+ 3.703000000000e-06 9.038783200074e-01
+ 3.704000000000e-06 9.041222815416e-01
+ 3.705000000000e-06 9.043662430759e-01
+ 3.706000000000e-06 9.046102046102e-01
+ 3.707000000000e-06 9.048541661445e-01
+ 3.708000000000e-06 9.050981276788e-01
+ 3.709000000000e-06 9.053420892131e-01
+ 3.710000000000e-06 9.055860507473e-01
+ 3.711000000000e-06 9.058300122816e-01
+ 3.712000000000e-06 9.060739738159e-01
+ 3.713000000000e-06 9.063179353502e-01
+ 3.714000000000e-06 9.065618968845e-01
+ 3.715000000000e-06 9.068058584188e-01
+ 3.716000000000e-06 9.070498199530e-01
+ 3.717000000000e-06 9.072937814873e-01
+ 3.718000000000e-06 9.075377430216e-01
+ 3.719000000000e-06 9.077817045559e-01
+ 3.720000000000e-06 9.080256660902e-01
+ 3.721000000000e-06 9.082696276245e-01
+ 3.722000000000e-06 9.085135891588e-01
+ 3.723000000000e-06 9.087575506930e-01
+ 3.724000000000e-06 9.090015122273e-01
+ 3.725000000000e-06 9.092454737616e-01
+ 3.726000000000e-06 9.094894352959e-01
+ 3.727000000000e-06 9.097333968302e-01
+ 3.728000000000e-06 9.099773583645e-01
+ 3.729000000000e-06 9.102213198987e-01
+ 3.730000000000e-06 9.104652814330e-01
+ 3.731000000000e-06 9.107092429673e-01
+ 3.732000000000e-06 9.109532045016e-01
+ 3.733000000000e-06 9.111971660359e-01
+ 3.734000000000e-06 9.114411275702e-01
+ 3.735000000000e-06 9.116850891044e-01
+ 3.736000000000e-06 9.119290506387e-01
+ 3.737000000000e-06 9.121730121730e-01
+ 3.738000000000e-06 9.124169737073e-01
+ 3.739000000000e-06 9.126609352416e-01
+ 3.740000000000e-06 9.129048967759e-01
+ 3.741000000000e-06 9.131488583101e-01
+ 3.742000000000e-06 9.133928198444e-01
+ 3.743000000000e-06 9.136367813787e-01
+ 3.744000000000e-06 9.138807429130e-01
+ 3.745000000000e-06 9.141247044473e-01
+ 3.746000000000e-06 9.143686659816e-01
+ 3.747000000000e-06 9.146126275159e-01
+ 3.748000000000e-06 9.148565890501e-01
+ 3.749000000000e-06 9.151005505844e-01
+ 3.750000000000e-06 9.153445121187e-01
+ 3.751000000000e-06 9.155884736530e-01
+ 3.752000000000e-06 9.158324351873e-01
+ 3.753000000000e-06 9.160763967216e-01
+ 3.754000000000e-06 9.163203582558e-01
+ 3.755000000000e-06 9.165643197901e-01
+ 3.756000000000e-06 9.168082813244e-01
+ 3.757000000000e-06 9.170522428587e-01
+ 3.758000000000e-06 9.172962043930e-01
+ 3.759000000000e-06 9.175401659273e-01
+ 3.760000000000e-06 9.177841274615e-01
+ 3.761000000000e-06 9.180280889958e-01
+ 3.762000000000e-06 9.182720505301e-01
+ 3.763000000000e-06 9.185160120644e-01
+ 3.764000000000e-06 9.187599735987e-01
+ 3.765000000000e-06 9.190039351330e-01
+ 3.766000000000e-06 9.192478966673e-01
+ 3.767000000000e-06 9.194918582015e-01
+ 3.768000000000e-06 9.197358197358e-01
+ 3.769000000000e-06 9.199797812701e-01
+ 3.770000000000e-06 9.202237428044e-01
+ 3.771000000000e-06 9.204677043387e-01
+ 3.772000000000e-06 9.207116658730e-01
+ 3.773000000000e-06 9.209556274072e-01
+ 3.774000000000e-06 9.211995889415e-01
+ 3.775000000000e-06 9.214435504758e-01
+ 3.776000000000e-06 9.216875120101e-01
+ 3.777000000000e-06 9.219314735444e-01
+ 3.778000000000e-06 9.221754350787e-01
+ 3.779000000000e-06 9.224193966129e-01
+ 3.780000000000e-06 9.226633581472e-01
+ 3.781000000000e-06 9.229073196815e-01
+ 3.782000000000e-06 9.231512812158e-01
+ 3.783000000000e-06 9.233952427501e-01
+ 3.784000000000e-06 9.236392042844e-01
+ 3.785000000000e-06 9.238831658186e-01
+ 3.786000000000e-06 9.241271273529e-01
+ 3.787000000000e-06 9.243710888872e-01
+ 3.788000000000e-06 9.246150504215e-01
+ 3.789000000000e-06 9.248590119558e-01
+ 3.790000000000e-06 9.251029734901e-01
+ 3.791000000000e-06 9.253469350244e-01
+ 3.792000000000e-06 9.255908965586e-01
+ 3.793000000000e-06 9.258348580929e-01
+ 3.794000000000e-06 9.260788196272e-01
+ 3.795000000000e-06 9.263227811615e-01
+ 3.796000000000e-06 9.265667426958e-01
+ 3.797000000000e-06 9.268107042301e-01
+ 3.798000000000e-06 9.270546657643e-01
+ 3.799000000000e-06 9.272986272986e-01
+ 3.800000000000e-06 9.275425888329e-01
+ 3.801000000000e-06 9.277865503672e-01
+ 3.802000000000e-06 9.280305119015e-01
+ 3.803000000000e-06 9.282744734358e-01
+ 3.804000000000e-06 9.285184349700e-01
+ 3.805000000000e-06 9.287623965043e-01
+ 3.806000000000e-06 9.290063580386e-01
+ 3.807000000000e-06 9.292503195729e-01
+ 3.808000000000e-06 9.294942811072e-01
+ 3.809000000000e-06 9.297382426415e-01
+ 3.810000000000e-06 9.299822041758e-01
+ 3.811000000000e-06 9.302261657100e-01
+ 3.812000000000e-06 9.304701272443e-01
+ 3.813000000000e-06 9.307140887786e-01
+ 3.814000000000e-06 9.309580503129e-01
+ 3.815000000000e-06 9.312020118472e-01
+ 3.816000000000e-06 9.314459733815e-01
+ 3.817000000000e-06 9.316899349157e-01
+ 3.818000000000e-06 9.319338964500e-01
+ 3.819000000000e-06 9.321778579843e-01
+ 3.820000000000e-06 9.324218195186e-01
+ 3.821000000000e-06 9.326657810529e-01
+ 3.822000000000e-06 9.329097425872e-01
+ 3.823000000000e-06 9.331537041214e-01
+ 3.824000000000e-06 9.333976656557e-01
+ 3.825000000000e-06 9.336416271900e-01
+ 3.826000000000e-06 9.338855887243e-01
+ 3.827000000000e-06 9.341295502586e-01
+ 3.828000000000e-06 9.343735117929e-01
+ 3.829000000000e-06 9.346174733272e-01
+ 3.830000000000e-06 9.348614348614e-01
+ 3.831000000000e-06 9.351053963957e-01
+ 3.832000000000e-06 9.353493579300e-01
+ 3.833000000000e-06 9.355933194643e-01
+ 3.834000000000e-06 9.358372809986e-01
+ 3.835000000000e-06 9.360812425329e-01
+ 3.836000000000e-06 9.363252040671e-01
+ 3.837000000000e-06 9.365691656014e-01
+ 3.838000000000e-06 9.368131271357e-01
+ 3.839000000000e-06 9.370570886700e-01
+ 3.840000000000e-06 9.373010502043e-01
+ 3.841000000000e-06 9.375450117386e-01
+ 3.842000000000e-06 9.377889732728e-01
+ 3.843000000000e-06 9.380329348071e-01
+ 3.844000000000e-06 9.382768963414e-01
+ 3.845000000000e-06 9.385208578757e-01
+ 3.846000000000e-06 9.387648194100e-01
+ 3.847000000000e-06 9.390087809443e-01
+ 3.848000000000e-06 9.392527424785e-01
+ 3.849000000000e-06 9.394967040128e-01
+ 3.850000000000e-06 9.397406655471e-01
+ 3.851000000000e-06 9.399846270814e-01
+ 3.852000000000e-06 9.402285886157e-01
+ 3.853000000000e-06 9.404725501500e-01
+ 3.854000000000e-06 9.407165116843e-01
+ 3.855000000000e-06 9.409604732185e-01
+ 3.856000000000e-06 9.412044347528e-01
+ 3.857000000000e-06 9.414483962871e-01
+ 3.858000000000e-06 9.416923578214e-01
+ 3.859000000000e-06 9.419363193557e-01
+ 3.860000000000e-06 9.421802808900e-01
+ 3.861000000000e-06 9.424242424242e-01
+ 3.862000000000e-06 9.426682039585e-01
+ 3.863000000000e-06 9.429121654928e-01
+ 3.864000000000e-06 9.431561270271e-01
+ 3.865000000000e-06 9.434000885614e-01
+ 3.866000000000e-06 9.436440500957e-01
+ 3.867000000000e-06 9.438880116299e-01
+ 3.868000000000e-06 9.441319731642e-01
+ 3.869000000000e-06 9.443759346985e-01
+ 3.870000000000e-06 9.446198962328e-01
+ 3.871000000000e-06 9.448638577671e-01
+ 3.872000000000e-06 9.451078193014e-01
+ 3.873000000000e-06 9.453517808357e-01
+ 3.874000000000e-06 9.455957423699e-01
+ 3.875000000000e-06 9.458397039042e-01
+ 3.876000000000e-06 9.460836654385e-01
+ 3.877000000000e-06 9.463276269728e-01
+ 3.878000000000e-06 9.465715885071e-01
+ 3.879000000000e-06 9.468155500414e-01
+ 3.880000000000e-06 9.470595115756e-01
+ 3.881000000000e-06 9.473034731099e-01
+ 3.882000000000e-06 9.475474346442e-01
+ 3.883000000000e-06 9.477913961785e-01
+ 3.884000000000e-06 9.480353577128e-01
+ 3.885000000000e-06 9.482793192471e-01
+ 3.886000000000e-06 9.485232807813e-01
+ 3.887000000000e-06 9.487672423156e-01
+ 3.888000000000e-06 9.490112038499e-01
+ 3.889000000000e-06 9.492551653842e-01
+ 3.890000000000e-06 9.494991269185e-01
+ 3.891000000000e-06 9.497430884528e-01
+ 3.892000000000e-06 9.499870499870e-01
+ 3.893000000000e-06 9.502310115213e-01
+ 3.894000000000e-06 9.504749730556e-01
+ 3.895000000000e-06 9.507189345899e-01
+ 3.896000000000e-06 9.509628961242e-01
+ 3.897000000000e-06 9.512068576585e-01
+ 3.898000000000e-06 9.514508191928e-01
+ 3.899000000000e-06 9.516947807270e-01
+ 3.900000000000e-06 9.519387422613e-01
+ 3.901000000000e-06 9.521827037956e-01
+ 3.902000000000e-06 9.524266653299e-01
+ 3.903000000000e-06 9.526706268642e-01
+ 3.904000000000e-06 9.529145883985e-01
+ 3.905000000000e-06 9.531585499327e-01
+ 3.906000000000e-06 9.534025114670e-01
+ 3.907000000000e-06 9.536464730013e-01
+ 3.908000000000e-06 9.538904345356e-01
+ 3.909000000000e-06 9.541343960699e-01
+ 3.910000000000e-06 9.543783576042e-01
+ 3.911000000000e-06 9.546223191384e-01
+ 3.912000000000e-06 9.548662806727e-01
+ 3.913000000000e-06 9.551102422070e-01
+ 3.914000000000e-06 9.553542037413e-01
+ 3.915000000000e-06 9.555981652756e-01
+ 3.916000000000e-06 9.558421268099e-01
+ 3.917000000000e-06 9.560860883442e-01
+ 3.918000000000e-06 9.563300498784e-01
+ 3.919000000000e-06 9.565740114127e-01
+ 3.920000000000e-06 9.568179729470e-01
+ 3.921000000000e-06 9.570619344813e-01
+ 3.922000000000e-06 9.573058960156e-01
+ 3.923000000000e-06 9.575498575499e-01
+ 3.924000000000e-06 9.577938190841e-01
+ 3.925000000000e-06 9.580377806184e-01
+ 3.926000000000e-06 9.582817421527e-01
+ 3.927000000000e-06 9.585257036870e-01
+ 3.928000000000e-06 9.587696652213e-01
+ 3.929000000000e-06 9.590136267556e-01
+ 3.930000000000e-06 9.592575882898e-01
+ 3.931000000000e-06 9.595015498241e-01
+ 3.932000000000e-06 9.597455113584e-01
+ 3.933000000000e-06 9.599894728927e-01
+ 3.934000000000e-06 9.602334344270e-01
+ 3.935000000000e-06 9.604773959613e-01
+ 3.936000000000e-06 9.607213574956e-01
+ 3.937000000000e-06 9.609653190298e-01
+ 3.938000000000e-06 9.612092805641e-01
+ 3.939000000000e-06 9.614532420984e-01
+ 3.940000000000e-06 9.616972036327e-01
+ 3.941000000000e-06 9.619411651670e-01
+ 3.942000000000e-06 9.621851267013e-01
+ 3.943000000000e-06 9.624290882355e-01
+ 3.944000000000e-06 9.626730497698e-01
+ 3.945000000000e-06 9.629170113041e-01
+ 3.946000000000e-06 9.631609728384e-01
+ 3.947000000000e-06 9.634049343727e-01
+ 3.948000000000e-06 9.636488959070e-01
+ 3.949000000000e-06 9.638928574412e-01
+ 3.950000000000e-06 9.641368189755e-01
+ 3.951000000000e-06 9.643807805098e-01
+ 3.952000000000e-06 9.646247420441e-01
+ 3.953000000000e-06 9.648687035784e-01
+ 3.954000000000e-06 9.651126651127e-01
+ 3.955000000000e-06 9.653566266469e-01
+ 3.956000000000e-06 9.656005881812e-01
+ 3.957000000000e-06 9.658445497155e-01
+ 3.958000000000e-06 9.660885112498e-01
+ 3.959000000000e-06 9.663324727841e-01
+ 3.960000000000e-06 9.665764343184e-01
+ 3.961000000000e-06 9.668203958527e-01
+ 3.962000000000e-06 9.670643573869e-01
+ 3.963000000000e-06 9.673083189212e-01
+ 3.964000000000e-06 9.675522804555e-01
+ 3.965000000000e-06 9.677962419898e-01
+ 3.966000000000e-06 9.680402035241e-01
+ 3.967000000000e-06 9.682841650584e-01
+ 3.968000000000e-06 9.685281265926e-01
+ 3.969000000000e-06 9.687720881269e-01
+ 3.970000000000e-06 9.690160496612e-01
+ 3.971000000000e-06 9.692600111955e-01
+ 3.972000000000e-06 9.695039727298e-01
+ 3.973000000000e-06 9.697479342641e-01
+ 3.974000000000e-06 9.699918957983e-01
+ 3.975000000000e-06 9.702358573326e-01
+ 3.976000000000e-06 9.704798188669e-01
+ 3.977000000000e-06 9.707237804012e-01
+ 3.978000000000e-06 9.709677419355e-01
+ 3.979000000000e-06 9.712117034698e-01
+ 3.980000000000e-06 9.714556650041e-01
+ 3.981000000000e-06 9.716996265383e-01
+ 3.982000000000e-06 9.719435880726e-01
+ 3.983000000000e-06 9.721875496069e-01
+ 3.984000000000e-06 9.724315111412e-01
+ 3.985000000000e-06 9.726754726755e-01
+ 3.986000000000e-06 9.729194342098e-01
+ 3.987000000000e-06 9.731633957440e-01
+ 3.988000000000e-06 9.734073572783e-01
+ 3.989000000000e-06 9.736513188126e-01
+ 3.990000000000e-06 9.738952803469e-01
+ 3.991000000000e-06 9.741392418812e-01
+ 3.992000000000e-06 9.743832034155e-01
+ 3.993000000000e-06 9.746271649497e-01
+ 3.994000000000e-06 9.748711264840e-01
+ 3.995000000000e-06 9.751150880183e-01
+ 3.996000000000e-06 9.753590495526e-01
+ 3.997000000000e-06 9.756030110869e-01
+ 3.998000000000e-06 9.758469726212e-01
+ 3.999000000000e-06 9.760909341555e-01
+ 4.000000000000e-06 9.763348956897e-01
+ 4.001000000000e-06 9.765788572240e-01
+ 4.002000000000e-06 9.768228187583e-01
+ 4.003000000000e-06 9.770667802926e-01
+ 4.004000000000e-06 9.773107418269e-01
+ 4.005000000000e-06 9.775547033612e-01
+ 4.006000000000e-06 9.777986648954e-01
+ 4.007000000000e-06 9.780426264297e-01
+ 4.008000000000e-06 9.782865879640e-01
+ 4.009000000000e-06 9.785305494983e-01
+ 4.010000000000e-06 9.787745110326e-01
+ 4.011000000000e-06 9.790184725669e-01
+ 4.012000000000e-06 9.792624341011e-01
+ 4.013000000000e-06 9.795063956354e-01
+ 4.014000000000e-06 9.797503571697e-01
+ 4.015000000000e-06 9.799943187040e-01
+ 4.016000000000e-06 9.802382802383e-01
+ 4.017000000000e-06 9.804822417726e-01
+ 4.018000000000e-06 9.807262033068e-01
+ 4.019000000000e-06 9.809701648411e-01
+ 4.020000000000e-06 9.812141263754e-01
+ 4.021000000000e-06 9.814580879097e-01
+ 4.022000000000e-06 9.817020494440e-01
+ 4.023000000000e-06 9.819460109783e-01
+ 4.024000000000e-06 9.821899725126e-01
+ 4.025000000000e-06 9.824339340468e-01
+ 4.026000000000e-06 9.826778955811e-01
+ 4.027000000000e-06 9.829218571154e-01
+ 4.028000000000e-06 9.831658186497e-01
+ 4.029000000000e-06 9.834097801840e-01
+ 4.030000000000e-06 9.836537417183e-01
+ 4.031000000000e-06 9.838977032525e-01
+ 4.032000000000e-06 9.841416647868e-01
+ 4.033000000000e-06 9.843856263211e-01
+ 4.034000000000e-06 9.846295878554e-01
+ 4.035000000000e-06 9.848735493897e-01
+ 4.036000000000e-06 9.851175109240e-01
+ 4.037000000000e-06 9.853614724582e-01
+ 4.038000000000e-06 9.856054339925e-01
+ 4.039000000000e-06 9.858493955268e-01
+ 4.040000000000e-06 9.860933570611e-01
+ 4.041000000000e-06 9.863373185954e-01
+ 4.042000000000e-06 9.865812801297e-01
+ 4.043000000000e-06 9.868252416640e-01
+ 4.044000000000e-06 9.870692031982e-01
+ 4.045000000000e-06 9.873131647325e-01
+ 4.046000000000e-06 9.875571262668e-01
+ 4.047000000000e-06 9.878010878011e-01
+ 4.048000000000e-06 9.880450493354e-01
+ 4.049000000000e-06 9.882890108697e-01
+ 4.050000000000e-06 9.885329724039e-01
+ 4.051000000000e-06 9.887769339382e-01
+ 4.052000000000e-06 9.890208954725e-01
+ 4.053000000000e-06 9.892648570068e-01
+ 4.054000000000e-06 9.895088185411e-01
+ 4.055000000000e-06 9.897527800754e-01
+ 4.056000000000e-06 9.899967416096e-01
+ 4.057000000000e-06 9.902407031439e-01
+ 4.058000000000e-06 9.904846646782e-01
+ 4.059000000000e-06 9.907286262125e-01
+ 4.060000000000e-06 9.909725877468e-01
+ 4.061000000000e-06 9.912165492811e-01
+ 4.062000000000e-06 9.914605108153e-01
+ 4.063000000000e-06 9.917044723496e-01
+ 4.064000000000e-06 9.919484338839e-01
+ 4.065000000000e-06 9.921923954182e-01
+ 4.066000000000e-06 9.924363569525e-01
+ 4.067000000000e-06 9.926803184868e-01
+ 4.068000000000e-06 9.929242800211e-01
+ 4.069000000000e-06 9.931682415553e-01
+ 4.070000000000e-06 9.934122030896e-01
+ 4.071000000000e-06 9.936561646239e-01
+ 4.072000000000e-06 9.939001261582e-01
+ 4.073000000000e-06 9.941440876925e-01
+ 4.074000000000e-06 9.943880492268e-01
+ 4.075000000000e-06 9.946320107610e-01
+ 4.076000000000e-06 9.948759722953e-01
+ 4.077000000000e-06 9.951199338296e-01
+ 4.078000000000e-06 9.953638953639e-01
+ 4.079000000000e-06 9.956078568982e-01
+ 4.080000000000e-06 9.958518184325e-01
+ 4.081000000000e-06 9.960957799667e-01
+ 4.082000000000e-06 9.963397415010e-01
+ 4.083000000000e-06 9.965837030353e-01
+ 4.084000000000e-06 9.968276645696e-01
+ 4.085000000000e-06 9.970716261039e-01
+ 4.086000000000e-06 9.973155876382e-01
+ 4.087000000000e-06 9.975595491725e-01
+ 4.088000000000e-06 9.978035107067e-01
+ 4.089000000000e-06 9.980474722410e-01
+ 4.090000000000e-06 9.982914337753e-01
+ 4.091000000000e-06 9.985353953096e-01
+ 4.092000000000e-06 9.987793568439e-01
+ 4.093000000000e-06 9.990233183782e-01
+ 4.094000000000e-06 9.992672799124e-01
+ 4.095000000000e-06 9.995112414467e-01
+ )
Vclk0 clk0 0 PULSE(0 1 0.000000000000e+00 100p 100p 2.000000000000e-09 4.000000000000e-09)
Bgain0 v_gain0 0 V={ 1.000000000000e+00*V(vin)+0.000000000000e+00 }
Bnonlin0 v_nl0 0 V={ V(v_gain0) + VFS*(NONLINEARITY_A2*pow((V(v_gain0)-VCM)/VFS,2) + NONLINEARITY_A3*pow((V(v_gain0)-VCM)/VFS,3)) }
Bquant0 v_code0 0 V={ ( V(v_nl0) <= VREFN ? 0 : V(v_nl0) >= VREFP ? MAXCODE : floor((V(v_nl0)-VREFN)/LSB+0.5) ) * LSB }
Vclk1 clk1 0 PULSE(0 1 1.000000000000e-09 100p 100p 2.000000000000e-09 4.000000000000e-09)
Bgain1 v_gain1 0 V={ 1.000000000000e+00*V(vin)+0.000000000000e+00 }
Bnonlin1 v_nl1 0 V={ V(v_gain1) + VFS*(NONLINEARITY_A2*pow((V(v_gain1)-VCM)/VFS,2) + NONLINEARITY_A3*pow((V(v_gain1)-VCM)/VFS,3)) }
Bquant1 v_code1 0 V={ ( V(v_nl1) <= VREFN ? 0 : V(v_nl1) >= VREFP ? MAXCODE : floor((V(v_nl1)-VREFN)/LSB+0.5) ) * LSB }
Vclk2 clk2 0 PULSE(0 1 2.000000000000e-09 100p 100p 2.000000000000e-09 4.000000000000e-09)
Bgain2 v_gain2 0 V={ 1.000000000000e+00*V(vin)+0.000000000000e+00 }
Bnonlin2 v_nl2 0 V={ V(v_gain2) + VFS*(NONLINEARITY_A2*pow((V(v_gain2)-VCM)/VFS,2) + NONLINEARITY_A3*pow((V(v_gain2)-VCM)/VFS,3)) }
Bquant2 v_code2 0 V={ ( V(v_nl2) <= VREFN ? 0 : V(v_nl2) >= VREFP ? MAXCODE : floor((V(v_nl2)-VREFN)/LSB+0.5) ) * LSB }
Vclk3 clk3 0 PULSE(0 1 3.000000000000e-09 100p 100p 2.000000000000e-09 4.000000000000e-09)
Bgain3 v_gain3 0 V={ 1.000000000000e+00*V(vin)+0.000000000000e+00 }
Bnonlin3 v_nl3 0 V={ V(v_gain3) + VFS*(NONLINEARITY_A2*pow((V(v_gain3)-VCM)/VFS,2) + NONLINEARITY_A3*pow((V(v_gain3)-VCM)/VFS,3)) }
Bquant3 v_code3 0 V={ ( V(v_nl3) <= VREFN ? 0 : V(v_nl3) >= VREFP ? MAXCODE : floor((V(v_nl3)-VREFN)/LSB+0.5) ) * LSB }

.control
tran 1.000000000000e-09 4.096000000000e-06
set wr_singlescale
wrdata /home/yongfu/proj/ti-adc-model/outputs/ngspice/ideal/logs/ti_static_inl_dnl.wrdata v(vin) v(clk0) v(v_code0) v(clk1) v(v_code1) v(clk2) v(v_code2) v(clk3) v(v_code3)
.endc
.end
